* Created by mapped OpenRule1um bridge

* cell VCO
.SUBCKT VCO P19 P28 P29 P1 P30 P17 P22
* net 1 GND
* net 19 Vout
* net 28 VDD
* net 29 VDD
* net 30 VSS
* device instance $1 r0 *1 205.3,84.1 pchor1ex
M$1 P28 P22 P22 P29 pchor1ex L=10U W=6U AS=12P AD=6P PS=16U PD=8U
* device instance $2 r0 *1 217.3,84.1 pchor1ex
M$2 P22 P22 P28 P29 pchor1ex L=10U W=6U AS=6P AD=12P PS=8U PD=16U
* device instance $3 r0 *1 476.3,83.1 pchor1ex
M$3 P27 P22 P28 P29 pchor1ex L=5U W=3U AS=6P AD=3P PS=10U PD=5U
* device instance $4 r0 *1 483.3,83.1 pchor1ex
M$4 P28 P22 P27 P29 pchor1ex L=5U W=3U AS=3P AD=3P PS=5U PD=5U
* device instance $5 r0 *1 490.3,83.1 pchor1ex
M$5 P27 P22 P28 P29 pchor1ex L=5U W=3U AS=3P AD=3P PS=5U PD=5U
* device instance $6 r0 *1 497.3,83.1 pchor1ex
M$6 P28 P22 P27 P29 pchor1ex L=5U W=3U AS=3P AD=6P PS=5U PD=10U
* device instance $7 r0 *1 437.3,83.1 pchor1ex
M$7 P26 P22 P28 P29 pchor1ex L=5U W=3U AS=6P AD=3P PS=10U PD=5U
* device instance $8 r0 *1 444.3,83.1 pchor1ex
M$8 P28 P22 P26 P29 pchor1ex L=5U W=3U AS=3P AD=3P PS=5U PD=5U
* device instance $9 r0 *1 451.3,83.1 pchor1ex
M$9 P26 P22 P28 P29 pchor1ex L=5U W=3U AS=3P AD=3P PS=5U PD=5U
* device instance $10 r0 *1 458.3,83.1 pchor1ex
M$10 P28 P22 P26 P29 pchor1ex L=5U W=3U AS=3P AD=6P PS=5U PD=10U
* device instance $11 r0 *1 398.3,83.1 pchor1ex
M$11 P21 P22 P28 P29 pchor1ex L=5U W=3U AS=6P AD=3P PS=10U PD=5U
* device instance $12 r0 *1 405.3,83.1 pchor1ex
M$12 P28 P22 P21 P29 pchor1ex L=5U W=3U AS=3P AD=3P PS=5U PD=5U
* device instance $13 r0 *1 412.3,83.1 pchor1ex
M$13 P21 P22 P28 P29 pchor1ex L=5U W=3U AS=3P AD=3P PS=5U PD=5U
* device instance $14 r0 *1 419.3,83.1 pchor1ex
M$14 P28 P22 P21 P29 pchor1ex L=5U W=3U AS=3P AD=6P PS=5U PD=10U
* device instance $15 r0 *1 320.3,83.1 pchor1ex
M$15 P24 P22 P28 P29 pchor1ex L=5U W=3U AS=6P AD=3P PS=10U PD=5U
* device instance $16 r0 *1 327.3,83.1 pchor1ex
M$16 P28 P22 P24 P29 pchor1ex L=5U W=3U AS=3P AD=3P PS=5U PD=5U
* device instance $17 r0 *1 334.3,83.1 pchor1ex
M$17 P24 P22 P28 P29 pchor1ex L=5U W=3U AS=3P AD=3P PS=5U PD=5U
* device instance $18 r0 *1 341.3,83.1 pchor1ex
M$18 P28 P22 P24 P29 pchor1ex L=5U W=3U AS=3P AD=6P PS=5U PD=10U
* device instance $19 r0 *1 332.4,66.1 pchor1ex
M$19 P4 P3 P24 P29 pchor1ex L=1U W=3U AS=6P AD=6P PS=10U PD=10U
* device instance $20 r0 *1 281.3,83.1 pchor1ex
M$20 P23 P22 P28 P29 pchor1ex L=5U W=3U AS=6P AD=3P PS=10U PD=5U
* device instance $21 r0 *1 288.3,83.1 pchor1ex
M$21 P28 P22 P23 P29 pchor1ex L=5U W=3U AS=3P AD=3P PS=5U PD=5U
* device instance $22 r0 *1 295.3,83.1 pchor1ex
M$22 P23 P22 P28 P29 pchor1ex L=5U W=3U AS=3P AD=3P PS=5U PD=5U
* device instance $23 r0 *1 302.3,83.1 pchor1ex
M$23 P28 P22 P23 P29 pchor1ex L=5U W=3U AS=3P AD=6P PS=5U PD=10U
* device instance $24 r0 *1 359.3,83.1 pchor1ex
M$24 P25 P22 P28 P29 pchor1ex L=5U W=3U AS=6P AD=3P PS=10U PD=5U
* device instance $25 r0 *1 366.3,83.1 pchor1ex
M$25 P28 P22 P25 P29 pchor1ex L=5U W=3U AS=3P AD=3P PS=5U PD=5U
* device instance $26 r0 *1 373.3,83.1 pchor1ex
M$26 P25 P22 P28 P29 pchor1ex L=5U W=3U AS=3P AD=3P PS=5U PD=5U
* device instance $27 r0 *1 380.3,83.1 pchor1ex
M$27 P28 P22 P25 P29 pchor1ex L=5U W=3U AS=3P AD=6P PS=5U PD=10U
* device instance $28 r0 *1 530.5,66.1 pchor1ex
M$28 P19 P18 P28 P29 pchor1ex L=1U W=3U AS=6P AD=6P PS=10U PD=10U
* device instance $29 r0 *1 242.3,83.1 pchor1ex
M$29 P20 P22 P28 P29 pchor1ex L=5U W=3U AS=6P AD=3P PS=10U PD=5U
* device instance $30 r0 *1 249.3,83.1 pchor1ex
M$30 P28 P22 P20 P29 pchor1ex L=5U W=3U AS=3P AD=3P PS=5U PD=5U
* device instance $31 r0 *1 256.3,83.1 pchor1ex
M$31 P20 P22 P28 P29 pchor1ex L=5U W=3U AS=3P AD=3P PS=5U PD=5U
* device instance $32 r0 *1 263.3,83.1 pchor1ex
M$32 P28 P22 P20 P29 pchor1ex L=5U W=3U AS=3P AD=6P PS=5U PD=10U
* device instance $33 r0 *1 516.5,66.1 pchor1ex
M$33 P18 P8 P28 P29 pchor1ex L=1U W=3U AS=6P AD=6P PS=10U PD=10U
* device instance $34 r0 *1 449.4,66.1 pchor1ex
M$34 P7 P6 P26 P29 pchor1ex L=1U W=3U AS=6P AD=6P PS=10U PD=10U
* device instance $35 r0 *1 410.4,66.1 pchor1ex
M$35 P6 P5 P21 P29 pchor1ex L=1U W=3U AS=6P AD=6P PS=10U PD=10U
* device instance $36 r0 *1 371.4,66.1 pchor1ex
M$36 P5 P4 P25 P29 pchor1ex L=1U W=3U AS=6P AD=6P PS=10U PD=10U
* device instance $37 r0 *1 488.4,66.1 pchor1ex
M$37 P8 P7 P27 P29 pchor1ex L=1U W=3U AS=6P AD=6P PS=10U PD=10U
* device instance $38 r0 *1 254.4,66.1 pchor1ex
M$38 P2 P8 P20 P29 pchor1ex L=1U W=3U AS=6P AD=6P PS=10U PD=10U
* device instance $39 r0 *1 293.4,66.1 pchor1ex
M$39 P3 P2 P23 P29 pchor1ex L=1U W=3U AS=6P AD=6P PS=10U PD=10U
* device instance $40 r0 *1 205.4,40.9 nchor1ex
M$40 P9 P17 P1 P30 nchor1ex L=10U W=2U AS=4P AD=2P PS=8U PD=4U
* device instance $41 r0 *1 217.4,40.9 nchor1ex
M$41 P1 P17 P9 P30 nchor1ex L=10U W=2U AS=2P AD=4P PS=4U PD=8U
* device instance $42 r0 *1 242.2,41.6 nchor1ex
M$42 P10 P17 P1 P30 nchor1ex L=5U W=2U AS=4P AD=2P PS=8U PD=4U
* device instance $43 r0 *1 249.2,41.6 nchor1ex
M$43 P1 P17 P10 P30 nchor1ex L=5U W=2U AS=2P AD=2P PS=4U PD=4U
* device instance $44 r0 *1 256.2,41.6 nchor1ex
M$44 P10 P17 P1 P30 nchor1ex L=5U W=2U AS=2P AD=2P PS=4U PD=4U
* device instance $45 r0 *1 263.2,41.6 nchor1ex
M$45 P1 P17 P10 P30 nchor1ex L=5U W=2U AS=2P AD=4P PS=4U PD=8U
* device instance $46 r0 *1 281.2,41.6 nchor1ex
M$46 P11 P17 P1 P30 nchor1ex L=5U W=2U AS=4P AD=2P PS=8U PD=4U
* device instance $47 r0 *1 288.2,41.6 nchor1ex
M$47 P1 P17 P11 P30 nchor1ex L=5U W=2U AS=2P AD=2P PS=4U PD=4U
* device instance $48 r0 *1 295.2,41.6 nchor1ex
M$48 P11 P17 P1 P30 nchor1ex L=5U W=2U AS=2P AD=2P PS=4U PD=4U
* device instance $49 r0 *1 302.2,41.6 nchor1ex
M$49 P1 P17 P11 P30 nchor1ex L=5U W=2U AS=2P AD=4P PS=4U PD=8U
* device instance $50 r0 *1 320.2,41.6 nchor1ex
M$50 P12 P17 P1 P30 nchor1ex L=5U W=2U AS=4P AD=2P PS=8U PD=4U
* device instance $51 r0 *1 327.2,41.6 nchor1ex
M$51 P1 P17 P12 P30 nchor1ex L=5U W=2U AS=2P AD=2P PS=4U PD=4U
* device instance $52 r0 *1 334.2,41.6 nchor1ex
M$52 P12 P17 P1 P30 nchor1ex L=5U W=2U AS=2P AD=2P PS=4U PD=4U
* device instance $53 r0 *1 341.2,41.6 nchor1ex
M$53 P1 P17 P12 P30 nchor1ex L=5U W=2U AS=2P AD=4P PS=4U PD=8U
* device instance $54 r0 *1 359.2,41.6 nchor1ex
M$54 P13 P17 P1 P30 nchor1ex L=5U W=2U AS=4P AD=2P PS=8U PD=4U
* device instance $55 r0 *1 366.2,41.6 nchor1ex
M$55 P1 P17 P13 P30 nchor1ex L=5U W=2U AS=2P AD=2P PS=4U PD=4U
* device instance $56 r0 *1 373.2,41.6 nchor1ex
M$56 P13 P17 P1 P30 nchor1ex L=5U W=2U AS=2P AD=2P PS=4U PD=4U
* device instance $57 r0 *1 380.2,41.6 nchor1ex
M$57 P1 P17 P13 P30 nchor1ex L=5U W=2U AS=2P AD=4P PS=4U PD=8U
* device instance $58 r0 *1 398.2,41.6 nchor1ex
M$58 P14 P17 P1 P30 nchor1ex L=5U W=2U AS=4P AD=2P PS=8U PD=4U
* device instance $59 r0 *1 405.2,41.6 nchor1ex
M$59 P1 P17 P14 P30 nchor1ex L=5U W=2U AS=2P AD=2P PS=4U PD=4U
* device instance $60 r0 *1 412.2,41.6 nchor1ex
M$60 P14 P17 P1 P30 nchor1ex L=5U W=2U AS=2P AD=2P PS=4U PD=4U
* device instance $61 r0 *1 419.2,41.6 nchor1ex
M$61 P1 P17 P14 P30 nchor1ex L=5U W=2U AS=2P AD=4P PS=4U PD=8U
* device instance $62 r0 *1 437.2,41.6 nchor1ex
M$62 P15 P17 P1 P30 nchor1ex L=5U W=2U AS=4P AD=2P PS=8U PD=4U
* device instance $63 r0 *1 444.2,41.6 nchor1ex
M$63 P1 P17 P15 P30 nchor1ex L=5U W=2U AS=2P AD=2P PS=4U PD=4U
* device instance $64 r0 *1 451.2,41.6 nchor1ex
M$64 P15 P17 P1 P30 nchor1ex L=5U W=2U AS=2P AD=2P PS=4U PD=4U
* device instance $65 r0 *1 458.2,41.6 nchor1ex
M$65 P1 P17 P15 P30 nchor1ex L=5U W=2U AS=2P AD=4P PS=4U PD=8U
* device instance $66 r0 *1 476.2,41.6 nchor1ex
M$66 P16 P17 P1 P30 nchor1ex L=5U W=2U AS=4P AD=2P PS=8U PD=4U
* device instance $67 r0 *1 483.2,41.6 nchor1ex
M$67 P1 P17 P16 P30 nchor1ex L=5U W=2U AS=2P AD=2P PS=4U PD=4U
* device instance $68 r0 *1 490.2,41.6 nchor1ex
M$68 P16 P17 P1 P30 nchor1ex L=5U W=2U AS=2P AD=2P PS=4U PD=4U
* device instance $69 r0 *1 497.2,41.6 nchor1ex
M$69 P1 P17 P16 P30 nchor1ex L=5U W=2U AS=2P AD=4P PS=4U PD=8U
* device instance $70 r0 *1 205.3,63.2 nchor1ex
M$70 P22 P22 P9 P30 nchor1ex L=10U W=2U AS=4P AD=2P PS=8U PD=4U
* device instance $71 r0 *1 217.3,63.2 nchor1ex
M$71 P9 P22 P22 P30 nchor1ex L=10U W=2U AS=2P AD=4P PS=4U PD=8U
* device instance $72 r0 *1 254.4,54.6 nchor1ex
M$72 P2 P8 P10 P30 nchor1ex L=1U W=2U AS=4P AD=4P PS=8U PD=8U
* device instance $73 r0 *1 293.4,54.6 nchor1ex
M$73 P3 P2 P11 P30 nchor1ex L=1U W=2U AS=4P AD=4P PS=8U PD=8U
* device instance $74 r0 *1 332.4,54.6 nchor1ex
M$74 P4 P3 P12 P30 nchor1ex L=1U W=2U AS=4P AD=4P PS=8U PD=8U
* device instance $75 r0 *1 371.4,54.6 nchor1ex
M$75 P5 P4 P13 P30 nchor1ex L=1U W=2U AS=4P AD=4P PS=8U PD=8U
* device instance $76 r0 *1 410.4,54.6 nchor1ex
M$76 P6 P5 P14 P30 nchor1ex L=1U W=2U AS=4P AD=4P PS=8U PD=8U
* device instance $77 r0 *1 449.4,54.6 nchor1ex
M$77 P7 P6 P15 P30 nchor1ex L=1U W=2U AS=4P AD=4P PS=8U PD=8U
* device instance $78 r0 *1 488.4,54.6 nchor1ex
M$78 P8 P7 P16 P30 nchor1ex L=1U W=2U AS=4P AD=4P PS=8U PD=8U
* device instance $79 r0 *1 516.5,54.6 nchor1ex
M$79 P18 P8 P1 P30 nchor1ex L=1U W=2U AS=4P AD=4P PS=8U PD=8U
* device instance $80 r0 *1 530.5,54.6 nchor1ex
M$80 P19 P18 P1 P30 nchor1ex L=1U W=2U AS=4P AD=4P PS=8U PD=8U
* Legacy OpenRule1um poly-cap markers retained as explicit simulation caps.
CLEG1 P2 P1 poly_cap W=20 L=20
CLEG2 P3 P1 poly_cap W=20 L=20
CLEG3 P4 P1 poly_cap W=20 L=20
CLEG4 P5 P1 poly_cap W=20 L=20
CLEG5 P6 P1 poly_cap W=20 L=20
CLEG6 P7 P1 poly_cap W=20 L=20
CLEG7 P8 P1 poly_cap W=20 L=20
XPEX_TR1UM P30 P1 P10 P10:54 P10:55 P10:56 P10:57 P10:58 P10:59 P11 P11:60 P11:61 P11:62 P11:63 P11:64 P11:65 P12 P12:66 P12:67 P12:68 P12:69 P12:70 P12:71 P13 P13:72 P13:73 P13:74 P13:75 P13:76 P13:77 P14 P14:78 P14:79 P14:80 P14:81 P14:82 P14:83 P15 P15:84 P15:85 P15:86 P15:87 P15:88 P15:89 P16 P16:90 P16:91 P16:92 P16:93 P16:94 P16:95 P17 P17:100 P17:101 P17:96 P17:97 P17:98 P17:99 P18 P18:102 P18:103 P18:104 P18:105 P18:106 P18:107 P19 P19:108 P19:109 P19:110 P19:111 P19:112 P19:113 P1:0 P1:1 P1:2 P1:3 P1:4 P1:5 P2 P20 P20:114 P20:115 P20:116 P20:117 P20:118 P20:119 P21 P21:120 P21:121 P21:122 P21:123 P21:124 P21:125 P22 P22:126 P22:127 P22:128 P22:129 P22:130 P22:131 P23 P23:132 P23:133 P23:134 P23:135 P23:136 P23:137 P24 P24:138 P24:139 P24:140 P24:141 P24:142 P24:143 P25 P25:144 P25:145 P25:146 P25:147 P25:148 P25:149 P26 P26:150 P26:151 P26:152 P26:153 P26:154 P26:155 P27 P27:156 P27:157 P27:158 P27:159 P27:160 P27:161 P28 P28:162 P28:163 P28:164 P28:165 P28:166 P28:167 P29 P29:168 P29:169 P29:170 P29:171 P29:172 P29:173 P2:10 P2:11 P2:6 P2:7 P2:8 P2:9 P3 P30 P30:174 P30:175 P30:176 P30:177 P30:178 P30:179 P3:12 P3:13 P3:14 P3:15 P3:16 P3:17 P4 P4:18 P4:19 P4:20 P4:21 P4:22 P4:23 P5 P5:24 P5:25 P5:26 P5:27 P5:28 P5:29 P6 P6:30 P6:31 P6:32 P6:33 P6:34 P6:35 P7 P7:36 P7:37 P7:38 P7:39 P7:40 P7:41 P8 P8:42 P8:43 P8:44 P8:45 P8:46 P8:47 P9 P9:48 P9:49 P9:50 P9:51 P9:52 P9:53 tr1um_parasitics
.ENDS VCO

.SUBCKT tr1um_parasitics VSS P1 P10 P10:54 P10:55 P10:56 P10:57 P10:58 P10:59 P11 P11:60 P11:61 P11:62 P11:63 P11:64 P11:65 P12 P12:66 P12:67 P12:68 P12:69 P12:70 P12:71 P13 P13:72 P13:73 P13:74 P13:75 P13:76 P13:77 P14 P14:78 P14:79 P14:80 P14:81 P14:82 P14:83 P15 P15:84 P15:85 P15:86 P15:87 P15:88 P15:89 P16 P16:90 P16:91 P16:92 P16:93 P16:94 P16:95 P17 P17:100 P17:101 P17:96 P17:97 P17:98 P17:99 P18 P18:102 P18:103 P18:104 P18:105 P18:106 P18:107 P19 P19:108 P19:109 P19:110 P19:111 P19:112 P19:113 P1:0 P1:1 P1:2 P1:3 P1:4 P1:5 P2 P20 P20:114 P20:115 P20:116 P20:117 P20:118 P20:119 P21 P21:120 P21:121 P21:122 P21:123 P21:124 P21:125 P22 P22:126 P22:127 P22:128 P22:129 P22:130 P22:131 P23 P23:132 P23:133 P23:134 P23:135 P23:136 P23:137 P24 P24:138 P24:139 P24:140 P24:141 P24:142 P24:143 P25 P25:144 P25:145 P25:146 P25:147 P25:148 P25:149 P26 P26:150 P26:151 P26:152 P26:153 P26:154 P26:155 P27 P27:156 P27:157 P27:158 P27:159 P27:160 P27:161 P28 P28:162 P28:163 P28:164 P28:165 P28:166 P28:167 P29 P29:168 P29:169 P29:170 P29:171 P29:172 P29:173 P2:10 P2:11 P2:6 P2:7 P2:8 P2:9 P3 P30 P30:174 P30:175 P30:176 P30:177 P30:178 P30:179 P3:12 P3:13 P3:14 P3:15 P3:16 P3:17 P4 P4:18 P4:19 P4:20 P4:21 P4:22 P4:23 P5 P5:24 P5:25 P5:26 P5:27 P5:28 P5:29 P6 P6:30 P6:31 P6:32 P6:33 P6:34 P6:35 P7 P7:36 P7:37 P7:38 P7:39 P7:40 P7:41 P8 P8:42 P8:43 P8:44 P8:45 P8:46 P8:47 P9 P9:48 P9:49 P9:50 P9:51 P9:52 P9:53
CPEX1 P10:56 VSS 1.5080041152pF
CPEX2 P10:59 VSS 0.162155728pF
CPEX3 P11:62 VSS 1.5080041152pF
CPEX4 P11:65 VSS 0.162155728pF
CPEX5 P12:68 VSS 1.5080041152pF
CPEX6 P12:71 VSS 0.162155728pF
CPEX7 P13:74 VSS 1.5080041152pF
CPEX8 P13:77 VSS 0.162155728pF
CPEX9 P14:80 VSS 1.5080041152pF
CPEX10 P14:83 VSS 0.162155728pF
CPEX11 P15:86 VSS 1.5080041152pF
CPEX12 P15:89 VSS 0.162155728pF
CPEX13 P16:92 VSS 1.5080041152pF
CPEX14 P16:95 VSS 0.162155728pF
CPEX15 P17:101 VSS 0.162155728pF
CPEX16 P17:98 VSS 1.5080041152pF
CPEX17 P18:104 VSS 1.5080041152pF
CPEX18 P18:107 VSS 0.162155728pF
CPEX19 P19:110 VSS 1.5080041152pF
CPEX20 P19:113 VSS 0.162155728pF
CPEX21 P1:2 VSS 1.5080041152pF
CPEX22 P1:5 VSS 0.162155728pF
CPEX23 P20:116 VSS 1.5080041152pF
CPEX24 P20:119 VSS 0.162155728pF
CPEX25 P21:122 VSS 1.5080041152pF
CPEX26 P21:125 VSS 0.162155728pF
CPEX27 P22:128 VSS 1.5080041152pF
CPEX28 P22:131 VSS 0.162155728pF
CPEX29 P23:134 VSS 1.5080041152pF
CPEX30 P23:137 VSS 0.162155728pF
CPEX31 P24:140 VSS 1.5080041152pF
CPEX32 P24:143 VSS 0.162155728pF
CPEX33 P25:146 VSS 1.5080041152pF
CPEX34 P25:149 VSS 0.162155728pF
CPEX35 P26:152 VSS 1.5080041152pF
CPEX36 P26:155 VSS 0.162155728pF
CPEX37 P27:158 VSS 1.5080041152pF
CPEX38 P27:161 VSS 0.162155728pF
CPEX39 P28:164 VSS 1.5080041152pF
CPEX40 P28:167 VSS 0.162155728pF
CPEX41 P29:170 VSS 1.5080041152pF
CPEX42 P29:173 VSS 0.162155728pF
CPEX43 P2:11 VSS 0.162155728pF
CPEX44 P2:8 VSS 1.5080041152pF
CPEX45 P30:176 VSS 1.5080041152pF
CPEX46 P30:179 VSS 0.162155728pF
CPEX47 P3:14 VSS 1.5080041152pF
CPEX48 P3:17 VSS 0.162155728pF
CPEX49 P4:20 VSS 1.5080041152pF
CPEX50 P4:23 VSS 0.162155728pF
CPEX51 P5:26 VSS 1.5080041152pF
CPEX52 P5:29 VSS 0.162155728pF
CPEX53 P6:32 VSS 1.5080041152pF
CPEX54 P6:35 VSS 0.162155728pF
CPEX55 P7:38 VSS 1.5080041152pF
CPEX56 P7:41 VSS 0.162155728pF
CPEX57 P8:44 VSS 1.5080041152pF
CPEX58 P8:47 VSS 0.162155728pF
CPEX59 P9:50 VSS 1.5080041152pF
CPEX60 P9:53 VSS 0.162155728pF
CPEX61 P10:54 P17:100 1.03424pF
CPEX62 P10:54 P8:42 0.25856pF
CPEX63 P10:56 P11:65 6.048e-05pF
CPEX64 P10:56 P12:71 6.048e-05pF
CPEX65 P10:56 P13:77 6.048e-05pF
CPEX66 P10:56 P14:83 6.048e-05pF
CPEX67 P10:56 P15:89 6.048e-05pF
CPEX68 P10:56 P16:95 6.048e-05pF
CPEX69 P10:56 P17:101 6.048e-05pF
CPEX70 P10:56 P18:107 6.048e-05pF
CPEX71 P10:56 P19:113 6.048e-05pF
CPEX72 P10:56 P20:119 6.048e-05pF
CPEX73 P10:56 P21:125 6.048e-05pF
CPEX74 P10:59 P1:2 6.048e-05pF
CPEX75 P10:59 P2:8 6.048e-05pF
CPEX76 P10:59 P3:14 6.048e-05pF
CPEX77 P10:59 P4:20 6.048e-05pF
CPEX78 P10:59 P5:26 6.048e-05pF
CPEX79 P10:59 P6:32 6.048e-05pF
CPEX80 P10:59 P7:38 6.048e-05pF
CPEX81 P10:59 P8:44 6.048e-05pF
CPEX82 P10:59 P9:50 6.048e-05pF
CPEX83 P11:60 P17:100 1.03424pF
CPEX84 P11:60 P2:10 0.25856pF
CPEX85 P11:62 P12:71 6.048e-05pF
CPEX86 P11:62 P13:77 6.048e-05pF
CPEX87 P11:62 P14:83 6.048e-05pF
CPEX88 P11:62 P15:89 6.048e-05pF
CPEX89 P11:62 P16:95 6.048e-05pF
CPEX90 P11:62 P17:101 6.048e-05pF
CPEX91 P11:62 P18:107 6.048e-05pF
CPEX92 P11:62 P19:113 6.048e-05pF
CPEX93 P11:62 P20:119 6.048e-05pF
CPEX94 P11:62 P21:125 6.048e-05pF
CPEX95 P11:62 P22:131 6.048e-05pF
CPEX96 P11:65 P1:2 6.048e-05pF
CPEX97 P11:65 P2:8 6.048e-05pF
CPEX98 P11:65 P3:14 6.048e-05pF
CPEX99 P11:65 P4:20 6.048e-05pF
CPEX100 P11:65 P5:26 6.048e-05pF
CPEX101 P11:65 P6:32 6.048e-05pF
CPEX102 P11:65 P7:38 6.048e-05pF
CPEX103 P11:65 P8:44 6.048e-05pF
CPEX104 P11:65 P9:50 6.048e-05pF
CPEX105 P12:66 P17:100 1.03424pF
CPEX106 P12:66 P3:12 0.25856pF
CPEX107 P12:68 P13:77 6.048e-05pF
CPEX108 P12:68 P14:83 6.048e-05pF
CPEX109 P12:68 P15:89 6.048e-05pF
CPEX110 P12:68 P16:95 6.048e-05pF
CPEX111 P12:68 P17:101 6.048e-05pF
CPEX112 P12:68 P18:107 6.048e-05pF
CPEX113 P12:68 P19:113 6.048e-05pF
CPEX114 P12:68 P20:119 6.048e-05pF
CPEX115 P12:68 P21:125 6.048e-05pF
CPEX116 P12:68 P22:131 6.048e-05pF
CPEX117 P12:68 P23:137 6.048e-05pF
CPEX118 P12:71 P1:2 6.048e-05pF
CPEX119 P12:71 P2:8 6.048e-05pF
CPEX120 P12:71 P3:14 6.048e-05pF
CPEX121 P12:71 P4:20 6.048e-05pF
CPEX122 P12:71 P5:26 6.048e-05pF
CPEX123 P12:71 P6:32 6.048e-05pF
CPEX124 P12:71 P7:38 6.048e-05pF
CPEX125 P12:71 P8:44 6.048e-05pF
CPEX126 P12:71 P9:50 6.048e-05pF
CPEX127 P13:72 P17:100 1.03424pF
CPEX128 P13:72 P4:18 0.25856pF
CPEX129 P13:74 P14:83 6.048e-05pF
CPEX130 P13:74 P15:89 6.048e-05pF
CPEX131 P13:74 P16:95 6.048e-05pF
CPEX132 P13:74 P17:101 6.048e-05pF
CPEX133 P13:74 P18:107 6.048e-05pF
CPEX134 P13:74 P19:113 6.048e-05pF
CPEX135 P13:74 P20:119 6.048e-05pF
CPEX136 P13:74 P21:125 6.048e-05pF
CPEX137 P13:74 P22:131 6.048e-05pF
CPEX138 P13:74 P23:137 6.048e-05pF
CPEX139 P13:74 P24:143 6.048e-05pF
CPEX140 P13:77 P2:8 6.048e-05pF
CPEX141 P13:77 P3:14 6.048e-05pF
CPEX142 P13:77 P4:20 6.048e-05pF
CPEX143 P13:77 P5:26 6.048e-05pF
CPEX144 P13:77 P6:32 6.048e-05pF
CPEX145 P13:77 P7:38 6.048e-05pF
CPEX146 P13:77 P8:44 6.048e-05pF
CPEX147 P13:77 P9:50 6.048e-05pF
CPEX148 P14:78 P17:100 1.03424pF
CPEX149 P14:78 P5:24 0.25856pF
CPEX150 P14:80 P15:89 6.048e-05pF
CPEX151 P14:80 P16:95 6.048e-05pF
CPEX152 P14:80 P17:101 6.048e-05pF
CPEX153 P14:80 P18:107 6.048e-05pF
CPEX154 P14:80 P19:113 6.048e-05pF
CPEX155 P14:80 P20:119 6.048e-05pF
CPEX156 P14:80 P21:125 6.048e-05pF
CPEX157 P14:80 P22:131 6.048e-05pF
CPEX158 P14:80 P23:137 6.048e-05pF
CPEX159 P14:80 P24:143 6.048e-05pF
CPEX160 P14:80 P25:149 6.048e-05pF
CPEX161 P14:83 P3:14 6.048e-05pF
CPEX162 P14:83 P4:20 6.048e-05pF
CPEX163 P14:83 P5:26 6.048e-05pF
CPEX164 P14:83 P6:32 6.048e-05pF
CPEX165 P14:83 P7:38 6.048e-05pF
CPEX166 P14:83 P8:44 6.048e-05pF
CPEX167 P14:83 P9:50 6.048e-05pF
CPEX168 P15:84 P17:100 1.03424pF
CPEX169 P15:84 P6:30 0.25856pF
CPEX170 P15:86 P16:95 6.048e-05pF
CPEX171 P15:86 P17:101 6.048e-05pF
CPEX172 P15:86 P18:107 6.048e-05pF
CPEX173 P15:86 P19:113 6.048e-05pF
CPEX174 P15:86 P20:119 6.048e-05pF
CPEX175 P15:86 P21:125 6.048e-05pF
CPEX176 P15:86 P22:131 6.048e-05pF
CPEX177 P15:86 P23:137 6.048e-05pF
CPEX178 P15:86 P24:143 6.048e-05pF
CPEX179 P15:86 P25:149 6.048e-05pF
CPEX180 P15:86 P26:155 6.048e-05pF
CPEX181 P15:89 P4:20 6.048e-05pF
CPEX182 P15:89 P5:26 6.048e-05pF
CPEX183 P15:89 P6:32 6.048e-05pF
CPEX184 P15:89 P7:38 6.048e-05pF
CPEX185 P15:89 P8:44 6.048e-05pF
CPEX186 P15:89 P9:50 6.048e-05pF
CPEX187 P16:90 P17:100 1.03424pF
CPEX188 P16:90 P7:36 0.25856pF
CPEX189 P16:92 P17:101 6.048e-05pF
CPEX190 P16:92 P18:107 6.048e-05pF
CPEX191 P16:92 P19:113 6.048e-05pF
CPEX192 P16:92 P20:119 6.048e-05pF
CPEX193 P16:92 P21:125 6.048e-05pF
CPEX194 P16:92 P22:131 6.048e-05pF
CPEX195 P16:92 P23:137 6.048e-05pF
CPEX196 P16:92 P24:143 6.048e-05pF
CPEX197 P16:92 P25:149 6.048e-05pF
CPEX198 P16:92 P26:155 6.048e-05pF
CPEX199 P16:92 P27:161 6.048e-05pF
CPEX200 P16:95 P5:26 6.048e-05pF
CPEX201 P16:95 P6:32 6.048e-05pF
CPEX202 P16:95 P7:38 6.048e-05pF
CPEX203 P16:95 P8:44 6.048e-05pF
CPEX204 P16:95 P9:50 6.048e-05pF
CPEX205 P17:100 P1:0 7.7568pF
CPEX206 P17:100 P9:48 0.51712pF
CPEX207 P17:101 P6:32 6.048e-05pF
CPEX208 P17:101 P7:38 6.048e-05pF
CPEX209 P17:101 P8:44 6.048e-05pF
CPEX210 P17:101 P9:50 6.048e-05pF
CPEX211 P17:98 P18:107 6.048e-05pF
CPEX212 P17:98 P19:113 6.048e-05pF
CPEX213 P17:98 P20:119 6.048e-05pF
CPEX214 P17:98 P21:125 6.048e-05pF
CPEX215 P17:98 P22:131 6.048e-05pF
CPEX216 P17:98 P23:137 6.048e-05pF
CPEX217 P17:98 P24:143 6.048e-05pF
CPEX218 P17:98 P25:149 6.048e-05pF
CPEX219 P17:98 P26:155 6.048e-05pF
CPEX220 P17:98 P27:161 6.048e-05pF
CPEX221 P17:98 P28:167 6.048e-05pF
CPEX222 P18:102 P19:108 0.60608pF
CPEX223 P18:102 P1:0 0.25856pF
CPEX224 P18:102 P28:162 0.34752pF
CPEX225 P18:102 P8:42 0.60608pF
CPEX226 P18:104 P19:113 6.048e-05pF
CPEX227 P18:104 P20:119 6.048e-05pF
CPEX228 P18:104 P21:125 6.048e-05pF
CPEX229 P18:104 P22:131 6.048e-05pF
CPEX230 P18:104 P23:137 6.048e-05pF
CPEX231 P18:104 P24:143 6.048e-05pF
CPEX232 P18:104 P25:149 6.048e-05pF
CPEX233 P18:104 P26:155 6.048e-05pF
CPEX234 P18:104 P27:161 6.048e-05pF
CPEX235 P18:104 P28:167 6.048e-05pF
CPEX236 P18:104 P29:173 6.048e-05pF
CPEX237 P18:107 P7:38 6.048e-05pF
CPEX238 P18:107 P8:44 6.048e-05pF
CPEX239 P18:107 P9:50 6.048e-05pF
CPEX240 P19:110 P20:119 6.048e-05pF
CPEX241 P19:110 P21:125 6.048e-05pF
CPEX242 P19:110 P22:131 6.048e-05pF
CPEX243 P19:110 P23:137 6.048e-05pF
CPEX244 P19:110 P24:143 6.048e-05pF
CPEX245 P19:110 P25:149 6.048e-05pF
CPEX246 P19:110 P26:155 6.048e-05pF
CPEX247 P19:110 P27:161 6.048e-05pF
CPEX248 P19:110 P28:167 6.048e-05pF
CPEX249 P19:110 P29:173 6.048e-05pF
CPEX250 P19:110 P30:179 6.048e-05pF
CPEX251 P19:113 P8:44 6.048e-05pF
CPEX252 P19:113 P9:50 6.048e-05pF
CPEX253 P1:0 P8:42 0.25856pF
CPEX254 P1:2 P2:11 6.048e-05pF
CPEX255 P1:2 P3:17 6.048e-05pF
CPEX256 P1:2 P4:23 6.048e-05pF
CPEX257 P1:2 P5:29 6.048e-05pF
CPEX258 P1:2 P6:35 6.048e-05pF
CPEX259 P1:2 P7:41 6.048e-05pF
CPEX260 P1:2 P8:47 6.048e-05pF
CPEX261 P1:2 P9:53 6.048e-05pF
CPEX262 P20:114 P22:126 1.39008pF
CPEX263 P20:114 P8:42 0.34752pF
CPEX264 P20:116 P21:125 6.048e-05pF
CPEX265 P20:116 P22:131 6.048e-05pF
CPEX266 P20:116 P23:137 6.048e-05pF
CPEX267 P20:116 P24:143 6.048e-05pF
CPEX268 P20:116 P25:149 6.048e-05pF
CPEX269 P20:116 P26:155 6.048e-05pF
CPEX270 P20:116 P27:161 6.048e-05pF
CPEX271 P20:116 P28:167 6.048e-05pF
CPEX272 P20:116 P29:173 6.048e-05pF
CPEX273 P20:116 P30:179 6.048e-05pF
CPEX274 P20:119 P9:50 6.048e-05pF
CPEX275 P21:120 P22:126 1.39008pF
CPEX276 P21:120 P5:24 0.34752pF
CPEX277 P21:122 P22:131 6.048e-05pF
CPEX278 P21:122 P23:137 6.048e-05pF
CPEX279 P21:122 P24:143 6.048e-05pF
CPEX280 P21:122 P25:149 6.048e-05pF
CPEX281 P21:122 P26:155 6.048e-05pF
CPEX282 P21:122 P27:161 6.048e-05pF
CPEX283 P21:122 P28:167 6.048e-05pF
CPEX284 P21:122 P29:173 6.048e-05pF
CPEX285 P21:122 P30:179 6.048e-05pF
CPEX286 P22:126 P23:132 1.39008pF
CPEX287 P22:126 P24:138 1.39008pF
CPEX288 P22:126 P25:144 1.39008pF
CPEX289 P22:126 P26:150 1.39008pF
CPEX290 P22:126 P27:156 1.39008pF
CPEX291 P22:126 P28:162 11.12064pF
CPEX292 P22:126 P9:48 0.51712pF
CPEX293 P22:128 P23:137 6.048e-05pF
CPEX294 P22:128 P24:143 6.048e-05pF
CPEX295 P22:128 P25:149 6.048e-05pF
CPEX296 P22:128 P26:155 6.048e-05pF
CPEX297 P22:128 P27:161 6.048e-05pF
CPEX298 P22:128 P28:167 6.048e-05pF
CPEX299 P22:128 P29:173 6.048e-05pF
CPEX300 P22:128 P30:179 6.048e-05pF
CPEX301 P23:132 P2:10 0.34752pF
CPEX302 P23:134 P24:143 6.048e-05pF
CPEX303 P23:134 P25:149 6.048e-05pF
CPEX304 P23:134 P26:155 6.048e-05pF
CPEX305 P23:134 P27:161 6.048e-05pF
CPEX306 P23:134 P28:167 6.048e-05pF
CPEX307 P23:134 P29:173 6.048e-05pF
CPEX308 P23:134 P30:179 6.048e-05pF
CPEX309 P24:138 P3:12 0.34752pF
CPEX310 P24:140 P25:149 6.048e-05pF
CPEX311 P24:140 P26:155 6.048e-05pF
CPEX312 P24:140 P27:161 6.048e-05pF
CPEX313 P24:140 P28:167 6.048e-05pF
CPEX314 P24:140 P29:173 6.048e-05pF
CPEX315 P24:140 P30:179 6.048e-05pF
CPEX316 P25:144 P4:18 0.34752pF
CPEX317 P25:146 P26:155 6.048e-05pF
CPEX318 P25:146 P27:161 6.048e-05pF
CPEX319 P25:146 P28:167 6.048e-05pF
CPEX320 P25:146 P29:173 6.048e-05pF
CPEX321 P25:146 P30:179 6.048e-05pF
CPEX322 P26:150 P6:30 0.34752pF
CPEX323 P26:152 P27:161 6.048e-05pF
CPEX324 P26:152 P28:167 6.048e-05pF
CPEX325 P26:152 P29:173 6.048e-05pF
CPEX326 P26:152 P30:179 6.048e-05pF
CPEX327 P27:156 P7:36 0.34752pF
CPEX328 P27:158 P28:167 6.048e-05pF
CPEX329 P27:158 P29:173 6.048e-05pF
CPEX330 P27:158 P30:179 6.048e-05pF
CPEX331 P28:162 P8:42 0.34752pF
CPEX332 P28:164 P29:173 6.048e-05pF
CPEX333 P28:164 P30:179 6.048e-05pF
CPEX334 P29:170 P30:179 6.048e-05pF
CPEX335 P2:10 P3:12 0.60608pF
CPEX336 P2:10 P8:42 0.60608pF
CPEX337 P2:8 P3:17 6.048e-05pF
CPEX338 P2:8 P4:23 6.048e-05pF
CPEX339 P2:8 P5:29 6.048e-05pF
CPEX340 P2:8 P6:35 6.048e-05pF
CPEX341 P2:8 P7:41 6.048e-05pF
CPEX342 P2:8 P8:47 6.048e-05pF
CPEX343 P2:8 P9:53 6.048e-05pF
CPEX344 P3:12 P4:18 0.60608pF
CPEX345 P3:14 P4:23 6.048e-05pF
CPEX346 P3:14 P5:29 6.048e-05pF
CPEX347 P3:14 P6:35 6.048e-05pF
CPEX348 P3:14 P7:41 6.048e-05pF
CPEX349 P3:14 P8:47 6.048e-05pF
CPEX350 P3:14 P9:53 6.048e-05pF
CPEX351 P4:18 P5:24 0.60608pF
CPEX352 P4:20 P5:29 6.048e-05pF
CPEX353 P4:20 P6:35 6.048e-05pF
CPEX354 P4:20 P7:41 6.048e-05pF
CPEX355 P4:20 P8:47 6.048e-05pF
CPEX356 P4:20 P9:53 6.048e-05pF
CPEX357 P5:24 P6:30 0.60608pF
CPEX358 P5:26 P6:35 6.048e-05pF
CPEX359 P5:26 P7:41 6.048e-05pF
CPEX360 P5:26 P8:47 6.048e-05pF
CPEX361 P5:26 P9:53 6.048e-05pF
CPEX362 P6:30 P7:36 0.60608pF
CPEX363 P6:32 P7:41 6.048e-05pF
CPEX364 P6:32 P8:47 6.048e-05pF
CPEX365 P6:32 P9:53 6.048e-05pF
CPEX366 P7:36 P8:42 0.60608pF
CPEX367 P7:38 P8:47 6.048e-05pF
CPEX368 P7:38 P9:53 6.048e-05pF
CPEX369 P8:44 P9:53 6.048e-05pF
RPEX370 P1:0 P1:2 3.078625000e+01
RPEX371 P1:2 P1:1 3.078625000e+01
RPEX372 P1:3 P1:5 1.203650000e+00
RPEX373 P1:5 P1:4 1.203650000e+00
RPEX374 P2:6 P2:8 3.078625000e+01
RPEX375 P2:8 P2:7 3.078625000e+01
RPEX376 P2:9 P2:11 1.203650000e+00
RPEX377 P2:11 P2:10 1.203650000e+00
RPEX378 P3:12 P3:14 3.078625000e+01
RPEX379 P3:14 P3:13 3.078625000e+01
RPEX380 P3:15 P3:17 1.203650000e+00
RPEX381 P3:17 P3:16 1.203650000e+00
RPEX382 P4:18 P4:20 3.078625000e+01
RPEX383 P4:20 P4:19 3.078625000e+01
RPEX384 P4:21 P4:23 1.203650000e+00
RPEX385 P4:23 P4:22 1.203650000e+00
RPEX386 P5:24 P5:26 3.078625000e+01
RPEX387 P5:26 P5:25 3.078625000e+01
RPEX388 P5:27 P5:29 1.203650000e+00
RPEX389 P5:29 P5:28 1.203650000e+00
RPEX390 P6:30 P6:32 3.078625000e+01
RPEX391 P6:32 P6:31 3.078625000e+01
RPEX392 P6:33 P6:35 1.203650000e+00
RPEX393 P6:35 P6:34 1.203650000e+00
RPEX394 P7:36 P7:38 3.078625000e+01
RPEX395 P7:38 P7:37 3.078625000e+01
RPEX396 P7:39 P7:41 1.203650000e+00
RPEX397 P7:41 P7:40 1.203650000e+00
RPEX398 P8:42 P8:44 3.078625000e+01
RPEX399 P8:44 P8:43 3.078625000e+01
RPEX400 P8:45 P8:47 1.203650000e+00
RPEX401 P8:47 P8:46 1.203650000e+00
RPEX402 P9:48 P9:50 3.078625000e+01
RPEX403 P9:50 P9:49 3.078625000e+01
RPEX404 P9:51 P9:53 1.203650000e+00
RPEX405 P9:53 P9:52 1.203650000e+00
RPEX406 P10:54 P10:56 3.078625000e+01
RPEX407 P10:56 P10:55 3.078625000e+01
RPEX408 P10:57 P10:59 1.203650000e+00
RPEX409 P10:59 P10:58 1.203650000e+00
RPEX410 P11:60 P11:62 3.078625000e+01
RPEX411 P11:62 P11:61 3.078625000e+01
RPEX412 P11:63 P11:65 1.203650000e+00
RPEX413 P11:65 P11:64 1.203650000e+00
RPEX414 P12:66 P12:68 3.078625000e+01
RPEX415 P12:68 P12:67 3.078625000e+01
RPEX416 P12:69 P12:71 1.203650000e+00
RPEX417 P12:71 P12:70 1.203650000e+00
RPEX418 P13:72 P13:74 3.078625000e+01
RPEX419 P13:74 P13:73 3.078625000e+01
RPEX420 P13:75 P13:77 1.203650000e+00
RPEX421 P13:77 P13:76 1.203650000e+00
RPEX422 P14:78 P14:80 3.078625000e+01
RPEX423 P14:80 P14:79 3.078625000e+01
RPEX424 P14:81 P14:83 1.203650000e+00
RPEX425 P14:83 P14:82 1.203650000e+00
RPEX426 P15:84 P15:86 3.078625000e+01
RPEX427 P15:86 P15:85 3.078625000e+01
RPEX428 P15:87 P15:89 1.203650000e+00
RPEX429 P15:89 P15:88 1.203650000e+00
RPEX430 P16:90 P16:92 3.078625000e+01
RPEX431 P16:92 P16:91 3.078625000e+01
RPEX432 P16:93 P16:95 1.203650000e+00
RPEX433 P16:95 P16:94 1.203650000e+00
RPEX434 P17:96 P17:98 3.078625000e+01
RPEX435 P17:98 P17:97 3.078625000e+01
RPEX436 P17:99 P17:101 1.203650000e+00
RPEX437 P17:101 P17:100 1.203650000e+00
RPEX438 P18:102 P18:104 3.078625000e+01
RPEX439 P18:104 P18:103 3.078625000e+01
RPEX440 P18:105 P18:107 1.203650000e+00
RPEX441 P18:107 P18:106 1.203650000e+00
RPEX442 P19:108 P19:110 3.078625000e+01
RPEX443 P19:110 P19:109 3.078625000e+01
RPEX444 P19:111 P19:113 1.203650000e+00
RPEX445 P19:113 P19:112 1.203650000e+00
RPEX446 P20:114 P20:116 3.078625000e+01
RPEX447 P20:116 P20:115 3.078625000e+01
RPEX448 P20:117 P20:119 1.203650000e+00
RPEX449 P20:119 P20:118 1.203650000e+00
RPEX450 P21:120 P21:122 3.078625000e+01
RPEX451 P21:122 P21:121 3.078625000e+01
RPEX452 P21:123 P21:125 1.203650000e+00
RPEX453 P21:125 P21:124 1.203650000e+00
RPEX454 P22:126 P22:128 3.078625000e+01
RPEX455 P22:128 P22:127 3.078625000e+01
RPEX456 P22:129 P22:131 1.203650000e+00
RPEX457 P22:131 P22:130 1.203650000e+00
RPEX458 P23:132 P23:134 3.078625000e+01
RPEX459 P23:134 P23:133 3.078625000e+01
RPEX460 P23:135 P23:137 1.203650000e+00
RPEX461 P23:137 P23:136 1.203650000e+00
RPEX462 P24:138 P24:140 3.078625000e+01
RPEX463 P24:140 P24:139 3.078625000e+01
RPEX464 P24:141 P24:143 1.203650000e+00
RPEX465 P24:143 P24:142 1.203650000e+00
RPEX466 P25:144 P25:146 3.078625000e+01
RPEX467 P25:146 P25:145 3.078625000e+01
RPEX468 P25:147 P25:149 1.203650000e+00
RPEX469 P25:149 P25:148 1.203650000e+00
RPEX470 P26:150 P26:152 3.078625000e+01
RPEX471 P26:152 P26:151 3.078625000e+01
RPEX472 P26:153 P26:155 1.203650000e+00
RPEX473 P26:155 P26:154 1.203650000e+00
RPEX474 P27:156 P27:158 3.078625000e+01
RPEX475 P27:158 P27:157 3.078625000e+01
RPEX476 P27:159 P27:161 1.203650000e+00
RPEX477 P27:161 P27:160 1.203650000e+00
RPEX478 P28:162 P28:164 3.078625000e+01
RPEX479 P28:164 P28:163 3.078625000e+01
RPEX480 P28:165 P28:167 1.203650000e+00
RPEX481 P28:167 P28:166 1.203650000e+00
RPEX482 P29:168 P29:170 3.078625000e+01
RPEX483 P29:170 P29:169 3.078625000e+01
RPEX484 P29:171 P29:173 1.203650000e+00
RPEX485 P29:173 P29:172 1.203650000e+00
RPEX486 P30:174 P30:176 3.078625000e+01
RPEX487 P30:176 P30:175 3.078625000e+01
RPEX488 P30:177 P30:179 1.203650000e+00
RPEX489 P30:179 P30:178 1.203650000e+00
RPEX490 P1:0 P1:3 1.000000000e+00
RPEX491 P2:6 P2:9 1.000000000e+00
RPEX492 P3:12 P3:15 1.000000000e+00
RPEX493 P4:18 P4:21 1.000000000e+00
RPEX494 P5:24 P5:27 1.000000000e+00
RPEX495 P6:30 P6:33 1.000000000e+00
RPEX496 P7:36 P7:39 1.000000000e+00
RPEX497 P8:42 P8:45 1.000000000e+00
RPEX498 P9:48 P9:51 1.000000000e+00
RPEX499 P10:54 P10:57 1.000000000e+00
RPEX500 P11:60 P11:63 1.000000000e+00
RPEX501 P12:66 P12:69 1.000000000e+00
RPEX502 P13:72 P13:75 1.000000000e+00
RPEX503 P14:78 P14:81 1.000000000e+00
RPEX504 P15:84 P15:87 1.000000000e+00
RPEX505 P16:90 P16:93 1.000000000e+00
RPEX506 P17:96 P17:99 1.000000000e+00
RPEX507 P18:102 P18:105 1.000000000e+00
RPEX508 P19:108 P19:111 1.000000000e+00
RPEX509 P20:114 P20:117 1.000000000e+00
RPEX510 P21:120 P21:123 1.000000000e+00
RPEX511 P22:126 P22:129 1.000000000e+00
RPEX512 P23:132 P23:135 1.000000000e+00
RPEX513 P24:138 P24:141 1.000000000e+00
RPEX514 P25:144 P25:147 1.000000000e+00
RPEX515 P26:150 P26:153 1.000000000e+00
RPEX516 P27:156 P27:159 1.000000000e+00
RPEX517 P28:162 P28:165 1.000000000e+00
RPEX518 P29:168 P29:171 1.000000000e+00
RPEX519 P30:174 P30:177 1.000000000e+00
RPEX520 P1 P1:3 1.000000000e-06
RPEX521 P2 P2:9 1.000000000e-06
RPEX522 P3 P3:12 1.000000000e-06
RPEX523 P4 P4:18 1.000000000e-06
RPEX524 P5 P5:27 1.000000000e-06
RPEX525 P6 P6:33 1.000000000e-06
RPEX526 P7 P7:39 1.000000000e-06
RPEX527 P8 P8:45 1.000000000e-06
RPEX528 P9 P9:48 1.000000000e-06
RPEX529 P10 P10:54 1.000000000e-06
RPEX530 P11 P11:63 1.000000000e-06
RPEX531 P12 P12:69 1.000000000e-06
RPEX532 P13 P13:75 1.000000000e-06
RPEX533 P14 P14:81 1.000000000e-06
RPEX534 P15 P15:84 1.000000000e-06
RPEX535 P16 P16:93 1.000000000e-06
RPEX536 P17 P17:99 1.000000000e-06
RPEX537 P18 P18:105 1.000000000e-06
RPEX538 P19 P19:111 1.000000000e-06
RPEX539 P20 P20:114 1.000000000e-06
RPEX540 P21 P21:123 1.000000000e-06
RPEX541 P22 P22:126 1.000000000e-06
RPEX542 P23 P23:132 1.000000000e-06
RPEX543 P24 P24:138 1.000000000e-06
RPEX544 P25 P25:144 1.000000000e-06
RPEX545 P26 P26:153 1.000000000e-06
RPEX546 P27 P27:159 1.000000000e-06
RPEX547 P28 P28:165 1.000000000e-06
RPEX548 P29 P29:168 1.000000000e-06
RPEX549 P30 P30:177 1.000000000e-06
.ENDS tr1um_parasitics
