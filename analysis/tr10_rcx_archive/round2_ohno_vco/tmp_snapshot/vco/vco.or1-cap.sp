* Created by KLayout

* cell VCO
.SUBCKT VCO
* net 18 Vout
* net 25 VDD
* net 28 GND
* device instance $1 r0 *1 271,20.5 POLY_CAP
C$1 1 28 1.224e-12 POLY_CAP
* device instance $2 r0 *1 466,20.5 POLY_CAP
C$2 6 28 1.224e-12 POLY_CAP
* device instance $3 r0 *1 349,20.5 POLY_CAP
C$3 3 28 1.224e-12 POLY_CAP
* device instance $4 r0 *1 505,20.5 POLY_CAP
C$4 7 28 1.224e-12 POLY_CAP
* device instance $5 r0 *1 388,20.5 POLY_CAP
C$5 4 28 1.224e-12 POLY_CAP
* device instance $6 r0 *1 310,20.5 POLY_CAP
C$6 2 28 1.224e-12 POLY_CAP
* device instance $7 r0 *1 427,20.5 POLY_CAP
C$7 5 28 1.224e-12 POLY_CAP
* device instance $8 r0 *1 205.3,84.1 PMOS
M$8 25 23 23 25 PMOS L=10U W=6U AS=12P AD=6P PS=16U PD=8U
* device instance $9 r0 *1 217.3,84.1 PMOS
M$9 23 23 25 25 PMOS L=10U W=6U AS=6P AD=12P PS=8U PD=16U
* device instance $10 r0 *1 476.3,83.1 PMOS
M$10 22 23 25 25 PMOS L=5U W=3U AS=6P AD=3P PS=10U PD=5U
* device instance $11 r0 *1 483.3,83.1 PMOS
M$11 25 23 22 25 PMOS L=5U W=3U AS=3P AD=3P PS=5U PD=5U
* device instance $12 r0 *1 490.3,83.1 PMOS
M$12 22 23 25 25 PMOS L=5U W=3U AS=3P AD=3P PS=5U PD=5U
* device instance $13 r0 *1 497.3,83.1 PMOS
M$13 25 23 22 25 PMOS L=5U W=3U AS=3P AD=6P PS=5U PD=10U
* device instance $14 r0 *1 437.3,83.1 PMOS
M$14 21 23 25 25 PMOS L=5U W=3U AS=6P AD=3P PS=10U PD=5U
* device instance $15 r0 *1 444.3,83.1 PMOS
M$15 25 23 21 25 PMOS L=5U W=3U AS=3P AD=3P PS=5U PD=5U
* device instance $16 r0 *1 451.3,83.1 PMOS
M$16 21 23 25 25 PMOS L=5U W=3U AS=3P AD=3P PS=5U PD=5U
* device instance $17 r0 *1 458.3,83.1 PMOS
M$17 25 23 21 25 PMOS L=5U W=3U AS=3P AD=6P PS=5U PD=10U
* device instance $18 r0 *1 398.3,83.1 PMOS
M$18 27 23 25 25 PMOS L=5U W=3U AS=6P AD=3P PS=10U PD=5U
* device instance $19 r0 *1 405.3,83.1 PMOS
M$19 25 23 27 25 PMOS L=5U W=3U AS=3P AD=3P PS=5U PD=5U
* device instance $20 r0 *1 412.3,83.1 PMOS
M$20 27 23 25 25 PMOS L=5U W=3U AS=3P AD=3P PS=5U PD=5U
* device instance $21 r0 *1 419.3,83.1 PMOS
M$21 25 23 27 25 PMOS L=5U W=3U AS=3P AD=6P PS=5U PD=10U
* device instance $22 r0 *1 320.3,83.1 PMOS
M$22 26 23 25 25 PMOS L=5U W=3U AS=6P AD=3P PS=10U PD=5U
* device instance $23 r0 *1 327.3,83.1 PMOS
M$23 25 23 26 25 PMOS L=5U W=3U AS=3P AD=3P PS=5U PD=5U
* device instance $24 r0 *1 334.3,83.1 PMOS
M$24 26 23 25 25 PMOS L=5U W=3U AS=3P AD=3P PS=5U PD=5U
* device instance $25 r0 *1 341.3,83.1 PMOS
M$25 25 23 26 25 PMOS L=5U W=3U AS=3P AD=6P PS=5U PD=10U
* device instance $26 r0 *1 332.4,66.1 PMOS
M$26 3 2 26 25 PMOS L=1U W=3U AS=6P AD=6P PS=10U PD=10U
* device instance $27 r0 *1 281.3,83.1 PMOS
M$27 19 23 25 25 PMOS L=5U W=3U AS=6P AD=3P PS=10U PD=5U
* device instance $28 r0 *1 288.3,83.1 PMOS
M$28 25 23 19 25 PMOS L=5U W=3U AS=3P AD=3P PS=5U PD=5U
* device instance $29 r0 *1 295.3,83.1 PMOS
M$29 19 23 25 25 PMOS L=5U W=3U AS=3P AD=3P PS=5U PD=5U
* device instance $30 r0 *1 302.3,83.1 PMOS
M$30 25 23 19 25 PMOS L=5U W=3U AS=3P AD=6P PS=5U PD=10U
* device instance $31 r0 *1 359.3,83.1 PMOS
M$31 20 23 25 25 PMOS L=5U W=3U AS=6P AD=3P PS=10U PD=5U
* device instance $32 r0 *1 366.3,83.1 PMOS
M$32 25 23 20 25 PMOS L=5U W=3U AS=3P AD=3P PS=5U PD=5U
* device instance $33 r0 *1 373.3,83.1 PMOS
M$33 20 23 25 25 PMOS L=5U W=3U AS=3P AD=3P PS=5U PD=5U
* device instance $34 r0 *1 380.3,83.1 PMOS
M$34 25 23 20 25 PMOS L=5U W=3U AS=3P AD=6P PS=5U PD=10U
* device instance $35 r0 *1 530.5,66.1 PMOS
M$35 18 17 25 25 PMOS L=1U W=3U AS=6P AD=6P PS=10U PD=10U
* device instance $36 r0 *1 242.3,83.1 PMOS
M$36 24 23 25 25 PMOS L=5U W=3U AS=6P AD=3P PS=10U PD=5U
* device instance $37 r0 *1 249.3,83.1 PMOS
M$37 25 23 24 25 PMOS L=5U W=3U AS=3P AD=3P PS=5U PD=5U
* device instance $38 r0 *1 256.3,83.1 PMOS
M$38 24 23 25 25 PMOS L=5U W=3U AS=3P AD=3P PS=5U PD=5U
* device instance $39 r0 *1 263.3,83.1 PMOS
M$39 25 23 24 25 PMOS L=5U W=3U AS=3P AD=6P PS=5U PD=10U
* device instance $40 r0 *1 516.5,66.1 PMOS
M$40 17 7 25 25 PMOS L=1U W=3U AS=6P AD=6P PS=10U PD=10U
* device instance $41 r0 *1 449.4,66.1 PMOS
M$41 6 5 21 25 PMOS L=1U W=3U AS=6P AD=6P PS=10U PD=10U
* device instance $42 r0 *1 410.4,66.1 PMOS
M$42 5 4 27 25 PMOS L=1U W=3U AS=6P AD=6P PS=10U PD=10U
* device instance $43 r0 *1 488.4,66.1 PMOS
M$43 7 6 22 25 PMOS L=1U W=3U AS=6P AD=6P PS=10U PD=10U
* device instance $44 r0 *1 371.4,66.1 PMOS
M$44 4 3 20 25 PMOS L=1U W=3U AS=6P AD=6P PS=10U PD=10U
* device instance $45 r0 *1 254.4,66.1 PMOS
M$45 1 7 24 25 PMOS L=1U W=3U AS=6P AD=6P PS=10U PD=10U
* device instance $46 r0 *1 293.4,66.1 PMOS
M$46 2 1 19 25 PMOS L=1U W=3U AS=6P AD=6P PS=10U PD=10U
* device instance $47 r0 *1 205.4,40.9 NMOS
M$47 8 13 28 28 NMOS L=10U W=2U AS=4P AD=2P PS=8U PD=4U
* device instance $48 r0 *1 217.4,40.9 NMOS
M$48 28 13 8 28 NMOS L=10U W=2U AS=2P AD=4P PS=4U PD=8U
* device instance $49 r0 *1 242.2,41.6 NMOS
M$49 9 13 28 28 NMOS L=5U W=2U AS=4P AD=2P PS=8U PD=4U
* device instance $50 r0 *1 249.2,41.6 NMOS
M$50 28 13 9 28 NMOS L=5U W=2U AS=2P AD=2P PS=4U PD=4U
* device instance $51 r0 *1 256.2,41.6 NMOS
M$51 9 13 28 28 NMOS L=5U W=2U AS=2P AD=2P PS=4U PD=4U
* device instance $52 r0 *1 263.2,41.6 NMOS
M$52 28 13 9 28 NMOS L=5U W=2U AS=2P AD=4P PS=4U PD=8U
* device instance $53 r0 *1 281.2,41.6 NMOS
M$53 10 13 28 28 NMOS L=5U W=2U AS=4P AD=2P PS=8U PD=4U
* device instance $54 r0 *1 288.2,41.6 NMOS
M$54 28 13 10 28 NMOS L=5U W=2U AS=2P AD=2P PS=4U PD=4U
* device instance $55 r0 *1 295.2,41.6 NMOS
M$55 10 13 28 28 NMOS L=5U W=2U AS=2P AD=2P PS=4U PD=4U
* device instance $56 r0 *1 302.2,41.6 NMOS
M$56 28 13 10 28 NMOS L=5U W=2U AS=2P AD=4P PS=4U PD=8U
* device instance $57 r0 *1 320.2,41.6 NMOS
M$57 14 13 28 28 NMOS L=5U W=2U AS=4P AD=2P PS=8U PD=4U
* device instance $58 r0 *1 327.2,41.6 NMOS
M$58 28 13 14 28 NMOS L=5U W=2U AS=2P AD=2P PS=4U PD=4U
* device instance $59 r0 *1 334.2,41.6 NMOS
M$59 14 13 28 28 NMOS L=5U W=2U AS=2P AD=2P PS=4U PD=4U
* device instance $60 r0 *1 341.2,41.6 NMOS
M$60 28 13 14 28 NMOS L=5U W=2U AS=2P AD=4P PS=4U PD=8U
* device instance $61 r0 *1 359.2,41.6 NMOS
M$61 11 13 28 28 NMOS L=5U W=2U AS=4P AD=2P PS=8U PD=4U
* device instance $62 r0 *1 366.2,41.6 NMOS
M$62 28 13 11 28 NMOS L=5U W=2U AS=2P AD=2P PS=4U PD=4U
* device instance $63 r0 *1 373.2,41.6 NMOS
M$63 11 13 28 28 NMOS L=5U W=2U AS=2P AD=2P PS=4U PD=4U
* device instance $64 r0 *1 380.2,41.6 NMOS
M$64 28 13 11 28 NMOS L=5U W=2U AS=2P AD=4P PS=4U PD=8U
* device instance $65 r0 *1 398.2,41.6 NMOS
M$65 15 13 28 28 NMOS L=5U W=2U AS=4P AD=2P PS=8U PD=4U
* device instance $66 r0 *1 405.2,41.6 NMOS
M$66 28 13 15 28 NMOS L=5U W=2U AS=2P AD=2P PS=4U PD=4U
* device instance $67 r0 *1 412.2,41.6 NMOS
M$67 15 13 28 28 NMOS L=5U W=2U AS=2P AD=2P PS=4U PD=4U
* device instance $68 r0 *1 419.2,41.6 NMOS
M$68 28 13 15 28 NMOS L=5U W=2U AS=2P AD=4P PS=4U PD=8U
* device instance $69 r0 *1 437.2,41.6 NMOS
M$69 12 13 28 28 NMOS L=5U W=2U AS=4P AD=2P PS=8U PD=4U
* device instance $70 r0 *1 444.2,41.6 NMOS
M$70 28 13 12 28 NMOS L=5U W=2U AS=2P AD=2P PS=4U PD=4U
* device instance $71 r0 *1 451.2,41.6 NMOS
M$71 12 13 28 28 NMOS L=5U W=2U AS=2P AD=2P PS=4U PD=4U
* device instance $72 r0 *1 458.2,41.6 NMOS
M$72 28 13 12 28 NMOS L=5U W=2U AS=2P AD=4P PS=4U PD=8U
* device instance $73 r0 *1 476.2,41.6 NMOS
M$73 16 13 28 28 NMOS L=5U W=2U AS=4P AD=2P PS=8U PD=4U
* device instance $74 r0 *1 483.2,41.6 NMOS
M$74 28 13 16 28 NMOS L=5U W=2U AS=2P AD=2P PS=4U PD=4U
* device instance $75 r0 *1 490.2,41.6 NMOS
M$75 16 13 28 28 NMOS L=5U W=2U AS=2P AD=2P PS=4U PD=4U
* device instance $76 r0 *1 497.2,41.6 NMOS
M$76 28 13 16 28 NMOS L=5U W=2U AS=2P AD=4P PS=4U PD=8U
* device instance $77 r0 *1 205.3,63.2 NMOS
M$77 23 23 8 28 NMOS L=10U W=2U AS=4P AD=2P PS=8U PD=4U
* device instance $78 r0 *1 217.3,63.2 NMOS
M$78 8 23 23 28 NMOS L=10U W=2U AS=2P AD=4P PS=4U PD=8U
* device instance $79 r0 *1 254.4,54.6 NMOS
M$79 1 7 9 28 NMOS L=1U W=2U AS=4P AD=4P PS=8U PD=8U
* device instance $80 r0 *1 293.4,54.6 NMOS
M$80 2 1 10 28 NMOS L=1U W=2U AS=4P AD=4P PS=8U PD=8U
* device instance $81 r0 *1 332.4,54.6 NMOS
M$81 3 2 14 28 NMOS L=1U W=2U AS=4P AD=4P PS=8U PD=8U
* device instance $82 r0 *1 371.4,54.6 NMOS
M$82 4 3 11 28 NMOS L=1U W=2U AS=4P AD=4P PS=8U PD=8U
* device instance $83 r0 *1 410.4,54.6 NMOS
M$83 5 4 15 28 NMOS L=1U W=2U AS=4P AD=4P PS=8U PD=8U
* device instance $84 r0 *1 449.4,54.6 NMOS
M$84 6 5 12 28 NMOS L=1U W=2U AS=4P AD=4P PS=8U PD=8U
* device instance $85 r0 *1 488.4,54.6 NMOS
M$85 7 6 16 28 NMOS L=1U W=2U AS=4P AD=4P PS=8U PD=8U
* device instance $86 r0 *1 516.5,54.6 NMOS
M$86 17 7 28 28 NMOS L=1U W=2U AS=4P AD=4P PS=8U PD=8U
* device instance $87 r0 *1 530.5,54.6 NMOS
M$87 18 17 28 28 NMOS L=1U W=2U AS=4P AD=4P PS=8U PD=8U
.ENDS VCO
