* Created by KLayout

* cell VCO
.SUBCKT VCO
* net 18 Vout
* net 24 VDD
* net 28 GND
* device instance $1 r0 *1 205.3,84.1 PMOS
M$1 24 23 23 24 PMOS L=10U W=6U AS=12P AD=6P PS=16U PD=8U
* device instance $2 r0 *1 217.3,84.1 PMOS
M$2 23 23 24 24 PMOS L=10U W=6U AS=6P AD=12P PS=8U PD=16U
* device instance $3 r0 *1 476.3,83.1 PMOS
M$3 22 23 24 24 PMOS L=5U W=3U AS=6P AD=3P PS=10U PD=5U
* device instance $4 r0 *1 483.3,83.1 PMOS
M$4 24 23 22 24 PMOS L=5U W=3U AS=3P AD=3P PS=5U PD=5U
* device instance $5 r0 *1 490.3,83.1 PMOS
M$5 22 23 24 24 PMOS L=5U W=3U AS=3P AD=3P PS=5U PD=5U
* device instance $6 r0 *1 497.3,83.1 PMOS
M$6 24 23 22 24 PMOS L=5U W=3U AS=3P AD=6P PS=5U PD=10U
* device instance $7 r0 *1 437.3,83.1 PMOS
M$7 27 23 24 24 PMOS L=5U W=3U AS=6P AD=3P PS=10U PD=5U
* device instance $8 r0 *1 444.3,83.1 PMOS
M$8 24 23 27 24 PMOS L=5U W=3U AS=3P AD=3P PS=5U PD=5U
* device instance $9 r0 *1 451.3,83.1 PMOS
M$9 27 23 24 24 PMOS L=5U W=3U AS=3P AD=3P PS=5U PD=5U
* device instance $10 r0 *1 458.3,83.1 PMOS
M$10 24 23 27 24 PMOS L=5U W=3U AS=3P AD=6P PS=5U PD=10U
* device instance $11 r0 *1 398.3,83.1 PMOS
M$11 26 23 24 24 PMOS L=5U W=3U AS=6P AD=3P PS=10U PD=5U
* device instance $12 r0 *1 405.3,83.1 PMOS
M$12 24 23 26 24 PMOS L=5U W=3U AS=3P AD=3P PS=5U PD=5U
* device instance $13 r0 *1 412.3,83.1 PMOS
M$13 26 23 24 24 PMOS L=5U W=3U AS=3P AD=3P PS=5U PD=5U
* device instance $14 r0 *1 419.3,83.1 PMOS
M$14 24 23 26 24 PMOS L=5U W=3U AS=3P AD=6P PS=5U PD=10U
* device instance $15 r0 *1 320.3,83.1 PMOS
M$15 20 23 24 24 PMOS L=5U W=3U AS=6P AD=3P PS=10U PD=5U
* device instance $16 r0 *1 327.3,83.1 PMOS
M$16 24 23 20 24 PMOS L=5U W=3U AS=3P AD=3P PS=5U PD=5U
* device instance $17 r0 *1 334.3,83.1 PMOS
M$17 20 23 24 24 PMOS L=5U W=3U AS=3P AD=3P PS=5U PD=5U
* device instance $18 r0 *1 341.3,83.1 PMOS
M$18 24 23 20 24 PMOS L=5U W=3U AS=3P AD=6P PS=5U PD=10U
* device instance $19 r0 *1 332.4,66.1 PMOS
M$19 3 2 20 24 PMOS L=1U W=3U AS=6P AD=6P PS=10U PD=10U
* device instance $20 r0 *1 281.3,83.1 PMOS
M$20 25 23 24 24 PMOS L=5U W=3U AS=6P AD=3P PS=10U PD=5U
* device instance $21 r0 *1 288.3,83.1 PMOS
M$21 24 23 25 24 PMOS L=5U W=3U AS=3P AD=3P PS=5U PD=5U
* device instance $22 r0 *1 295.3,83.1 PMOS
M$22 25 23 24 24 PMOS L=5U W=3U AS=3P AD=3P PS=5U PD=5U
* device instance $23 r0 *1 302.3,83.1 PMOS
M$23 24 23 25 24 PMOS L=5U W=3U AS=3P AD=6P PS=5U PD=10U
* device instance $24 r0 *1 359.3,83.1 PMOS
M$24 21 23 24 24 PMOS L=5U W=3U AS=6P AD=3P PS=10U PD=5U
* device instance $25 r0 *1 366.3,83.1 PMOS
M$25 24 23 21 24 PMOS L=5U W=3U AS=3P AD=3P PS=5U PD=5U
* device instance $26 r0 *1 373.3,83.1 PMOS
M$26 21 23 24 24 PMOS L=5U W=3U AS=3P AD=3P PS=5U PD=5U
* device instance $27 r0 *1 380.3,83.1 PMOS
M$27 24 23 21 24 PMOS L=5U W=3U AS=3P AD=6P PS=5U PD=10U
* device instance $28 r0 *1 530.5,66.1 PMOS
M$28 18 17 24 24 PMOS L=1U W=3U AS=6P AD=6P PS=10U PD=10U
* device instance $29 r0 *1 242.3,83.1 PMOS
M$29 19 23 24 24 PMOS L=5U W=3U AS=6P AD=3P PS=10U PD=5U
* device instance $30 r0 *1 249.3,83.1 PMOS
M$30 24 23 19 24 PMOS L=5U W=3U AS=3P AD=3P PS=5U PD=5U
* device instance $31 r0 *1 256.3,83.1 PMOS
M$31 19 23 24 24 PMOS L=5U W=3U AS=3P AD=3P PS=5U PD=5U
* device instance $32 r0 *1 263.3,83.1 PMOS
M$32 24 23 19 24 PMOS L=5U W=3U AS=3P AD=6P PS=5U PD=10U
* device instance $33 r0 *1 516.5,66.1 PMOS
M$33 17 7 24 24 PMOS L=1U W=3U AS=6P AD=6P PS=10U PD=10U
* device instance $34 r0 *1 449.4,66.1 PMOS
M$34 6 5 27 24 PMOS L=1U W=3U AS=6P AD=6P PS=10U PD=10U
* device instance $35 r0 *1 410.4,66.1 PMOS
M$35 5 4 26 24 PMOS L=1U W=3U AS=6P AD=6P PS=10U PD=10U
* device instance $36 r0 *1 488.4,66.1 PMOS
M$36 7 6 22 24 PMOS L=1U W=3U AS=6P AD=6P PS=10U PD=10U
* device instance $37 r0 *1 371.4,66.1 PMOS
M$37 4 3 21 24 PMOS L=1U W=3U AS=6P AD=6P PS=10U PD=10U
* device instance $38 r0 *1 254.4,66.1 PMOS
M$38 1 7 19 24 PMOS L=1U W=3U AS=6P AD=6P PS=10U PD=10U
* device instance $39 r0 *1 293.4,66.1 PMOS
M$39 2 1 25 24 PMOS L=1U W=3U AS=6P AD=6P PS=10U PD=10U
* device instance $40 r0 *1 205.4,40.9 NMOS
M$40 8 15 28 28 NMOS L=10U W=2U AS=4P AD=2P PS=8U PD=4U
* device instance $41 r0 *1 217.4,40.9 NMOS
M$41 28 15 8 28 NMOS L=10U W=2U AS=2P AD=4P PS=4U PD=8U
* device instance $42 r0 *1 242.2,41.6 NMOS
M$42 16 15 28 28 NMOS L=5U W=2U AS=4P AD=2P PS=8U PD=4U
* device instance $43 r0 *1 249.2,41.6 NMOS
M$43 28 15 16 28 NMOS L=5U W=2U AS=2P AD=2P PS=4U PD=4U
* device instance $44 r0 *1 256.2,41.6 NMOS
M$44 16 15 28 28 NMOS L=5U W=2U AS=2P AD=2P PS=4U PD=4U
* device instance $45 r0 *1 263.2,41.6 NMOS
M$45 28 15 16 28 NMOS L=5U W=2U AS=2P AD=4P PS=4U PD=8U
* device instance $46 r0 *1 281.2,41.6 NMOS
M$46 9 15 28 28 NMOS L=5U W=2U AS=4P AD=2P PS=8U PD=4U
* device instance $47 r0 *1 288.2,41.6 NMOS
M$47 28 15 9 28 NMOS L=5U W=2U AS=2P AD=2P PS=4U PD=4U
* device instance $48 r0 *1 295.2,41.6 NMOS
M$48 9 15 28 28 NMOS L=5U W=2U AS=2P AD=2P PS=4U PD=4U
* device instance $49 r0 *1 302.2,41.6 NMOS
M$49 28 15 9 28 NMOS L=5U W=2U AS=2P AD=4P PS=4U PD=8U
* device instance $50 r0 *1 320.2,41.6 NMOS
M$50 10 15 28 28 NMOS L=5U W=2U AS=4P AD=2P PS=8U PD=4U
* device instance $51 r0 *1 327.2,41.6 NMOS
M$51 28 15 10 28 NMOS L=5U W=2U AS=2P AD=2P PS=4U PD=4U
* device instance $52 r0 *1 334.2,41.6 NMOS
M$52 10 15 28 28 NMOS L=5U W=2U AS=2P AD=2P PS=4U PD=4U
* device instance $53 r0 *1 341.2,41.6 NMOS
M$53 28 15 10 28 NMOS L=5U W=2U AS=2P AD=4P PS=4U PD=8U
* device instance $54 r0 *1 359.2,41.6 NMOS
M$54 11 15 28 28 NMOS L=5U W=2U AS=4P AD=2P PS=8U PD=4U
* device instance $55 r0 *1 366.2,41.6 NMOS
M$55 28 15 11 28 NMOS L=5U W=2U AS=2P AD=2P PS=4U PD=4U
* device instance $56 r0 *1 373.2,41.6 NMOS
M$56 11 15 28 28 NMOS L=5U W=2U AS=2P AD=2P PS=4U PD=4U
* device instance $57 r0 *1 380.2,41.6 NMOS
M$57 28 15 11 28 NMOS L=5U W=2U AS=2P AD=4P PS=4U PD=8U
* device instance $58 r0 *1 398.2,41.6 NMOS
M$58 12 15 28 28 NMOS L=5U W=2U AS=4P AD=2P PS=8U PD=4U
* device instance $59 r0 *1 405.2,41.6 NMOS
M$59 28 15 12 28 NMOS L=5U W=2U AS=2P AD=2P PS=4U PD=4U
* device instance $60 r0 *1 412.2,41.6 NMOS
M$60 12 15 28 28 NMOS L=5U W=2U AS=2P AD=2P PS=4U PD=4U
* device instance $61 r0 *1 419.2,41.6 NMOS
M$61 28 15 12 28 NMOS L=5U W=2U AS=2P AD=4P PS=4U PD=8U
* device instance $62 r0 *1 437.2,41.6 NMOS
M$62 13 15 28 28 NMOS L=5U W=2U AS=4P AD=2P PS=8U PD=4U
* device instance $63 r0 *1 444.2,41.6 NMOS
M$63 28 15 13 28 NMOS L=5U W=2U AS=2P AD=2P PS=4U PD=4U
* device instance $64 r0 *1 451.2,41.6 NMOS
M$64 13 15 28 28 NMOS L=5U W=2U AS=2P AD=2P PS=4U PD=4U
* device instance $65 r0 *1 458.2,41.6 NMOS
M$65 28 15 13 28 NMOS L=5U W=2U AS=2P AD=4P PS=4U PD=8U
* device instance $66 r0 *1 476.2,41.6 NMOS
M$66 14 15 28 28 NMOS L=5U W=2U AS=4P AD=2P PS=8U PD=4U
* device instance $67 r0 *1 483.2,41.6 NMOS
M$67 28 15 14 28 NMOS L=5U W=2U AS=2P AD=2P PS=4U PD=4U
* device instance $68 r0 *1 490.2,41.6 NMOS
M$68 14 15 28 28 NMOS L=5U W=2U AS=2P AD=2P PS=4U PD=4U
* device instance $69 r0 *1 497.2,41.6 NMOS
M$69 28 15 14 28 NMOS L=5U W=2U AS=2P AD=4P PS=4U PD=8U
* device instance $70 r0 *1 205.3,63.2 NMOS
M$70 23 23 8 28 NMOS L=10U W=2U AS=4P AD=2P PS=8U PD=4U
* device instance $71 r0 *1 217.3,63.2 NMOS
M$71 8 23 23 28 NMOS L=10U W=2U AS=2P AD=4P PS=4U PD=8U
* device instance $72 r0 *1 254.4,54.6 NMOS
M$72 1 7 16 28 NMOS L=1U W=2U AS=4P AD=4P PS=8U PD=8U
* device instance $73 r0 *1 293.4,54.6 NMOS
M$73 2 1 9 28 NMOS L=1U W=2U AS=4P AD=4P PS=8U PD=8U
* device instance $74 r0 *1 332.4,54.6 NMOS
M$74 3 2 10 28 NMOS L=1U W=2U AS=4P AD=4P PS=8U PD=8U
* device instance $75 r0 *1 371.4,54.6 NMOS
M$75 4 3 11 28 NMOS L=1U W=2U AS=4P AD=4P PS=8U PD=8U
* device instance $76 r0 *1 410.4,54.6 NMOS
M$76 5 4 12 28 NMOS L=1U W=2U AS=4P AD=4P PS=8U PD=8U
* device instance $77 r0 *1 449.4,54.6 NMOS
M$77 6 5 13 28 NMOS L=1U W=2U AS=4P AD=4P PS=8U PD=8U
* device instance $78 r0 *1 488.4,54.6 NMOS
M$78 7 6 14 28 NMOS L=1U W=2U AS=4P AD=4P PS=8U PD=8U
* device instance $79 r0 *1 516.5,54.6 NMOS
M$79 17 7 28 28 NMOS L=1U W=2U AS=4P AD=4P PS=8U PD=8U
* device instance $80 r0 *1 530.5,54.6 NMOS
M$80 18 17 28 28 NMOS L=1U W=2U AS=4P AD=4P PS=8U PD=8U
.ENDS VCO
