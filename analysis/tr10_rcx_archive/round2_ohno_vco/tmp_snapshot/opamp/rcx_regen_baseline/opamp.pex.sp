* TR-1um engineering distributed parasitic RC network.
* Include this subcircuit only when its device-cap ownership is understood.
.SUBCKT tr1um_parasitics VSS P1 P10 P10:54 P10:55 P10:56 P10:57 P10:58 P10:59 P11 P11:60 P11:61 P11:62 P11:63 P11:64 P11:65 P12 P12:66 P12:67 P12:68 P12:69 P12:70 P12:71 P1:0 P1:1 P1:2 P1:3 P1:4 P1:5 P2 P2:10 P2:11 P2:6 P2:7 P2:8 P2:9 P3 P3:12 P3:13 P3:14 P3:15 P3:16 P3:17 P4 P4:18 P4:19 P4:20 P4:21 P4:22 P4:23 P5 P5:24 P5:25 P5:26 P5:27 P5:28 P5:29 P6 P6:30 P6:31 P6:32 P6:33 P6:34 P6:35 P7 P7:36 P7:37 P7:38 P7:39 P7:40 P7:41 P8 P8:42 P8:43 P8:44 P8:45 P8:46 P8:47 P9 P9:48 P9:49 P9:50 P9:51 P9:52 P9:53
CPEX1 P10:56 VSS 3.279299724e-01pF
CPEX2 P10:59 VSS 4.557314475e-02pF
CPEX3 P11:62 VSS 3.279299724e-01pF
CPEX4 P11:65 VSS 4.557314475e-02pF
CPEX5 P12:68 VSS 3.279299724e-01pF
CPEX6 P12:71 VSS 4.557314475e-02pF
CPEX7 P1:2 VSS 3.279299724e-01pF
CPEX8 P1:5 VSS 4.557314475e-02pF
CPEX9 P2:11 VSS 4.557314475e-02pF
CPEX10 P2:8 VSS 3.279299724e-01pF
CPEX11 P3:14 VSS 3.279299724e-01pF
CPEX12 P3:17 VSS 4.557314475e-02pF
CPEX13 P4:20 VSS 3.279299724e-01pF
CPEX14 P4:23 VSS 4.557314475e-02pF
CPEX15 P5:26 VSS 3.279299724e-01pF
CPEX16 P5:29 VSS 4.557314475e-02pF
CPEX17 P6:32 VSS 3.279299724e-01pF
CPEX18 P6:35 VSS 4.557314475e-02pF
CPEX19 P7:38 VSS 3.279299724e-01pF
CPEX20 P7:41 VSS 4.557314475e-02pF
CPEX21 P8:44 VSS 3.279299724e-01pF
CPEX22 P8:47 VSS 4.557314475e-02pF
CPEX23 P9:50 VSS 3.279299724e-01pF
CPEX24 P9:53 VSS 4.557314475e-02pF
CPEX25 P10:56 P11:62 1.532474000e-01pF
CPEX26 P10:56 P11:65 9.450000000e-07pF
CPEX27 P10:56 P12:68 1.522474000e-01pF
CPEX28 P10:56 P12:71 9.450000000e-07pF
CPEX29 P10:56 P1:2 1.452474000e-01pF
CPEX30 P10:56 P2:8 1.462474000e-01pF
CPEX31 P10:56 P3:14 1.472474000e-01pF
CPEX32 P10:56 P4:20 1.482474000e-01pF
CPEX33 P10:56 P5:26 1.492474000e-01pF
CPEX34 P10:56 P6:32 1.502474000e-01pF
CPEX35 P10:56 P7:38 1.512474000e-01pF
CPEX36 P10:56 P8:44 1.522474000e-01pF
CPEX37 P10:56 P9:50 1.532474000e-01pF
CPEX38 P10:59 P1:2 9.450000000e-07pF
CPEX39 P10:59 P2:8 9.450000000e-07pF
CPEX40 P10:59 P3:14 9.450000000e-07pF
CPEX41 P10:59 P4:20 9.450000000e-07pF
CPEX42 P10:59 P5:26 9.450000000e-07pF
CPEX43 P10:59 P6:32 9.450000000e-07pF
CPEX44 P10:59 P7:38 9.450000000e-07pF
CPEX45 P10:59 P8:44 9.450000000e-07pF
CPEX46 P10:59 P9:50 9.450000000e-07pF
CPEX47 P11:62 P12:68 1.532474000e-01pF
CPEX48 P11:62 P12:71 9.450000000e-07pF
CPEX49 P11:62 P1:2 1.442474000e-01pF
CPEX50 P11:62 P2:8 1.452474000e-01pF
CPEX51 P11:62 P3:14 1.462474000e-01pF
CPEX52 P11:62 P4:20 1.472474000e-01pF
CPEX53 P11:62 P5:26 1.482474000e-01pF
CPEX54 P11:62 P6:32 1.492474000e-01pF
CPEX55 P11:62 P7:38 1.502474000e-01pF
CPEX56 P11:62 P8:44 1.512474000e-01pF
CPEX57 P11:62 P9:50 1.522474000e-01pF
CPEX58 P11:65 P1:2 9.450000000e-07pF
CPEX59 P11:65 P2:8 9.450000000e-07pF
CPEX60 P11:65 P3:14 9.450000000e-07pF
CPEX61 P11:65 P4:20 9.450000000e-07pF
CPEX62 P11:65 P5:26 9.450000000e-07pF
CPEX63 P11:65 P6:32 9.450000000e-07pF
CPEX64 P11:65 P7:38 9.450000000e-07pF
CPEX65 P11:65 P8:44 9.450000000e-07pF
CPEX66 P11:65 P9:50 9.450000000e-07pF
CPEX67 P12:68 P1:2 1.432474000e-01pF
CPEX68 P12:68 P2:8 1.442474000e-01pF
CPEX69 P12:68 P3:14 1.452474000e-01pF
CPEX70 P12:68 P4:20 1.462474000e-01pF
CPEX71 P12:68 P5:26 1.472474000e-01pF
CPEX72 P12:68 P6:32 1.482474000e-01pF
CPEX73 P12:68 P7:38 1.492474000e-01pF
CPEX74 P12:68 P8:44 1.502474000e-01pF
CPEX75 P12:68 P9:50 1.512474000e-01pF
CPEX76 P12:71 P1:2 9.450000000e-07pF
CPEX77 P12:71 P2:8 9.450000000e-07pF
CPEX78 P12:71 P3:14 9.450000000e-07pF
CPEX79 P12:71 P4:20 9.450000000e-07pF
CPEX80 P12:71 P5:26 9.450000000e-07pF
CPEX81 P12:71 P6:32 9.450000000e-07pF
CPEX82 P12:71 P7:38 9.450000000e-07pF
CPEX83 P12:71 P8:44 9.450000000e-07pF
CPEX84 P12:71 P9:50 9.450000000e-07pF
CPEX85 P1:2 P2:11 9.450000000e-07pF
CPEX86 P1:2 P2:8 1.532474000e-01pF
CPEX87 P1:2 P3:14 1.522474000e-01pF
CPEX88 P1:2 P3:17 9.450000000e-07pF
CPEX89 P1:2 P4:20 1.512474000e-01pF
CPEX90 P1:2 P4:23 9.450000000e-07pF
CPEX91 P1:2 P5:26 1.502474000e-01pF
CPEX92 P1:2 P5:29 9.450000000e-07pF
CPEX93 P1:2 P6:32 1.492474000e-01pF
CPEX94 P1:2 P6:35 9.450000000e-07pF
CPEX95 P1:2 P7:38 1.482474000e-01pF
CPEX96 P1:2 P7:41 9.450000000e-07pF
CPEX97 P1:2 P8:44 1.472474000e-01pF
CPEX98 P1:2 P8:47 9.450000000e-07pF
CPEX99 P1:2 P9:50 1.462474000e-01pF
CPEX100 P1:2 P9:53 9.450000000e-07pF
CPEX101 P2:8 P3:14 1.532474000e-01pF
CPEX102 P2:8 P3:17 9.450000000e-07pF
CPEX103 P2:8 P4:20 1.522474000e-01pF
CPEX104 P2:8 P4:23 9.450000000e-07pF
CPEX105 P2:8 P5:26 1.512474000e-01pF
CPEX106 P2:8 P5:29 9.450000000e-07pF
CPEX107 P2:8 P6:32 1.502474000e-01pF
CPEX108 P2:8 P6:35 9.450000000e-07pF
CPEX109 P2:8 P7:38 1.492474000e-01pF
CPEX110 P2:8 P7:41 9.450000000e-07pF
CPEX111 P2:8 P8:44 1.482474000e-01pF
CPEX112 P2:8 P8:47 9.450000000e-07pF
CPEX113 P2:8 P9:50 1.472474000e-01pF
CPEX114 P2:8 P9:53 9.450000000e-07pF
CPEX115 P3:14 P4:20 1.532474000e-01pF
CPEX116 P3:14 P4:23 9.450000000e-07pF
CPEX117 P3:14 P5:26 1.522474000e-01pF
CPEX118 P3:14 P5:29 9.450000000e-07pF
CPEX119 P3:14 P6:32 1.512474000e-01pF
CPEX120 P3:14 P6:35 9.450000000e-07pF
CPEX121 P3:14 P7:38 1.502474000e-01pF
CPEX122 P3:14 P7:41 9.450000000e-07pF
CPEX123 P3:14 P8:44 1.492474000e-01pF
CPEX124 P3:14 P8:47 9.450000000e-07pF
CPEX125 P3:14 P9:50 1.482474000e-01pF
CPEX126 P3:14 P9:53 9.450000000e-07pF
CPEX127 P4:20 P5:26 1.532474000e-01pF
CPEX128 P4:20 P5:29 9.450000000e-07pF
CPEX129 P4:20 P6:32 1.522474000e-01pF
CPEX130 P4:20 P6:35 9.450000000e-07pF
CPEX131 P4:20 P7:38 1.512474000e-01pF
CPEX132 P4:20 P7:41 9.450000000e-07pF
CPEX133 P4:20 P8:44 1.502474000e-01pF
CPEX134 P4:20 P8:47 9.450000000e-07pF
CPEX135 P4:20 P9:50 1.492474000e-01pF
CPEX136 P4:20 P9:53 9.450000000e-07pF
CPEX137 P5:26 P6:32 1.532474000e-01pF
CPEX138 P5:26 P6:35 9.450000000e-07pF
CPEX139 P5:26 P7:38 1.522474000e-01pF
CPEX140 P5:26 P7:41 9.450000000e-07pF
CPEX141 P5:26 P8:44 1.512474000e-01pF
CPEX142 P5:26 P8:47 9.450000000e-07pF
CPEX143 P5:26 P9:50 1.502474000e-01pF
CPEX144 P5:26 P9:53 9.450000000e-07pF
CPEX145 P6:32 P7:38 1.532474000e-01pF
CPEX146 P6:32 P7:41 9.450000000e-07pF
CPEX147 P6:32 P8:44 1.522474000e-01pF
CPEX148 P6:32 P8:47 9.450000000e-07pF
CPEX149 P6:32 P9:50 1.512474000e-01pF
CPEX150 P6:32 P9:53 9.450000000e-07pF
CPEX151 P7:38 P8:44 1.532474000e-01pF
CPEX152 P7:38 P8:47 9.450000000e-07pF
CPEX153 P7:38 P9:50 1.522474000e-01pF
CPEX154 P7:38 P9:53 9.450000000e-07pF
CPEX155 P8:44 P9:50 1.532474000e-01pF
CPEX156 P8:44 P9:53 9.450000000e-07pF
RPEX157 P1:0 P1:2 4.284650000e+02
RPEX158 P1:2 P1:1 4.284650000e+02
RPEX159 P1:3 P1:5 2.164995000e+01
RPEX160 P1:5 P1:4 2.164995000e+01
RPEX161 P2:6 P2:8 4.284650000e+02
RPEX162 P2:8 P2:7 4.284650000e+02
RPEX163 P2:9 P2:11 2.164995000e+01
RPEX164 P2:11 P2:10 2.164995000e+01
RPEX165 P3:12 P3:14 4.284650000e+02
RPEX166 P3:14 P3:13 4.284650000e+02
RPEX167 P3:15 P3:17 2.164995000e+01
RPEX168 P3:17 P3:16 2.164995000e+01
RPEX169 P4:18 P4:20 4.284650000e+02
RPEX170 P4:20 P4:19 4.284650000e+02
RPEX171 P4:21 P4:23 2.164995000e+01
RPEX172 P4:23 P4:22 2.164995000e+01
RPEX173 P5:24 P5:26 4.284650000e+02
RPEX174 P5:26 P5:25 4.284650000e+02
RPEX175 P5:27 P5:29 2.164995000e+01
RPEX176 P5:29 P5:28 2.164995000e+01
RPEX177 P6:30 P6:32 4.284650000e+02
RPEX178 P6:32 P6:31 4.284650000e+02
RPEX179 P6:33 P6:35 2.164995000e+01
RPEX180 P6:35 P6:34 2.164995000e+01
RPEX181 P7:36 P7:38 4.284650000e+02
RPEX182 P7:38 P7:37 4.284650000e+02
RPEX183 P7:39 P7:41 2.164995000e+01
RPEX184 P7:41 P7:40 2.164995000e+01
RPEX185 P8:42 P8:44 4.284650000e+02
RPEX186 P8:44 P8:43 4.284650000e+02
RPEX187 P8:45 P8:47 2.164995000e+01
RPEX188 P8:47 P8:46 2.164995000e+01
RPEX189 P9:48 P9:50 4.284650000e+02
RPEX190 P9:50 P9:49 4.284650000e+02
RPEX191 P9:51 P9:53 2.164995000e+01
RPEX192 P9:53 P9:52 2.164995000e+01
RPEX193 P10:54 P10:56 4.284650000e+02
RPEX194 P10:56 P10:55 4.284650000e+02
RPEX195 P10:57 P10:59 2.164995000e+01
RPEX196 P10:59 P10:58 2.164995000e+01
RPEX197 P11:60 P11:62 4.284650000e+02
RPEX198 P11:62 P11:61 4.284650000e+02
RPEX199 P11:63 P11:65 2.164995000e+01
RPEX200 P11:65 P11:64 2.164995000e+01
RPEX201 P12:66 P12:68 4.284650000e+02
RPEX202 P12:68 P12:67 4.284650000e+02
RPEX203 P12:69 P12:71 2.164995000e+01
RPEX204 P12:71 P12:70 2.164995000e+01
RPEX205 P1:0 P1:3 1.000000000e+00
RPEX206 P2:6 P2:9 1.000000000e+00
RPEX207 P3:12 P3:15 1.000000000e+00
RPEX208 P4:18 P4:21 1.000000000e+00
RPEX209 P5:24 P5:27 1.000000000e+00
RPEX210 P6:30 P6:33 1.000000000e+00
RPEX211 P7:36 P7:39 1.000000000e+00
RPEX212 P8:42 P8:45 1.000000000e+00
RPEX213 P9:48 P9:51 1.000000000e+00
RPEX214 P10:54 P10:57 1.000000000e+00
RPEX215 P11:60 P11:63 1.000000000e+00
RPEX216 P12:66 P12:69 1.000000000e+00
RPEX217 P1 P1:0 0.000000000e+00
RPEX218 P2 P2:6 0.000000000e+00
RPEX219 P3 P3:12 0.000000000e+00
RPEX220 P4 P4:21 0.000000000e+00
RPEX221 P5 P5:27 0.000000000e+00
RPEX222 P6 P6:30 0.000000000e+00
RPEX223 P7 P7:36 0.000000000e+00
RPEX224 P8 P8:42 0.000000000e+00
RPEX225 P9 P9:51 0.000000000e+00
RPEX226 P10 P10:54 0.000000000e+00
RPEX227 P11 P11:60 0.000000000e+00
RPEX228 P12 P12:69 0.000000000e+00
.ENDS tr1um_parasitics
