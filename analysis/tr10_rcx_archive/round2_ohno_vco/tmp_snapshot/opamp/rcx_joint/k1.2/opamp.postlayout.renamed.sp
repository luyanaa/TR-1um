* TR-1um engineering post-layout SPICE merge.
* Device hierarchy is from KLayout GDS extraction; distributed RC is from the PEX sidecar.
* Status and unresolved mappings are recorded in the adjacent PEX manifest.
.include "/Users/yanlu/Documents/TR-1um/libs.tech/spice/models/ip62_models_calibrated"
* Begin device hierarchy: /private/tmp/tr10-rcx/opamp/rcx/opamp.devices.sp
* Created by KLayout

* cell TOP
* pin OUT
* pin VDD
* pin VSS
.SUBCKT OPAMP_OHNO P7 P9 P12 P10 P11 P1
* net 7 OUT
* net 9 VDD
* net 12 VSS
* device instance _1 r0 *1 121.3,-48.2 NMOS
X_1 P7 P5 P12 P12 NMOS L=3U W=270U AS=444P AD=444P PS=329.6U PD=329.6U
* device instance _10 m135 *1 -63.8,-67.9 NMOS
X_10 P5 P3 P2 P12 NMOS L=3U W=30U AS=84P AD=84P PS=65.6U PD=65.6U
* device instance _11 m90 *1 -208.8,58.1 PMOS
X_11 P3 P1 P9 P9 PMOS L=3U W=120U AS=219P AD=219P PS=164.6U PD=164.6U
* device instance _15 r0 *1 -162.7,58.1 PMOS
X_15 P6 P1 P9 P9 PMOS L=3U W=240U AS=399P AD=399P PS=296.6U PD=296.6U
* device instance _23 r0 *1 -192.1,-59 NMOS
X_23 P3 P3 P4 P12 NMOS L=3U W=60U AS=129P AD=129P PS=98.6U PD=98.6U
* device instance _25 r0 *1 -227.7,-59 NMOS
X_25 P4 P4 P12 P12 NMOS L=3U W=60U AS=129P AD=129P PS=98.6U PD=98.6U
* device instance _27 r270 *1 -130.7,-29.8 NMOS
X_27 P5 P8 P12 P12 NMOS L=3U W=60U AS=129P AD=129P PS=98.6U PD=98.6U
* device instance _29 m45 *1 -130.7,-0.4 NMOS
X_29 P8 P8 P12 P12 NMOS L=3U W=60U AS=129P AD=129P PS=98.6U PD=98.6U
* device instance _31 m135 *1 -219.8,8.7 PMOS
X_31 P1 P1 P9 P9 PMOS L=3U W=90U AS=174P AD=174P PS=131.6U PD=131.6U
* device instance _34 m0 *1 121.3,14.1 PMOS
X_34 P7 P1 P9 P9 PMOS L=3U W=540U AS=888P AD=888P PS=659.2U PD=659.2U
* device instance _52 r0 *1 271.8,23.3 CSIO
C_52 P7 P2 8.856e-12
* device instance _53 m0 *1 -74.5,-12.8 PMOS
X_53 P5 P10 P6 P6 PMOS L=3U W=720U AS=1158P AD=1158P PS=857.2U PD=857.2U
* device instance _77 r0 *1 -74.5,58.1 PMOS
X_77 P8 P11 P6 P6 PMOS L=3U W=720U AS=1158P AD=1158P PS=857.2U PD=857.2U
* Distributed RC ownership: wire/via/coupling network from the PEX sidecar.
XPEX_TR1UM P12 P1 P10 P10:54 P10:55 P10:56 P10:57 P10:58 P10:59 P11 P11:60 P11:61 P11:62 P11:63 P11:64 P11:65 P12:66 P12:67 P12:68 P12:69 P12:70 P12:71 P1:0 P1:1 P1:2 P1:3 P1:4 P1:5 P2 P2:10 P2:11 P2:6 P2:7 P2:8 P2:9 P3 P3:12 P3:13 P3:14 P3:15 P3:16 P3:17 P4 P4:18 P4:19 P4:20 P4:21 P4:22 P4:23 P5 P5:24 P5:25 P5:26 P5:27 P5:28 P5:29 P6 P6:30 P6:31 P6:32 P6:33 P6:34 P6:35 P7 P7:36 P7:37 P7:38 P7:39 P7:40 P7:41 P8 P8:42 P8:43 P8:44 P8:45 P8:46 P8:47 P9 P9:48 P9:49 P9:50 P9:51 P9:52 P9:53 tr1um_parasitics
.ENDS TOP
* Begin distributed interconnect: /private/tmp/tr10-rcx/opamp/rcx/opamp.pex.sp
* TR-1um engineering distributed parasitic RC network.
* Include this subcircuit only when its device-cap ownership is understood.
.SUBCKT tr1um_parasitics P12 P1 P10 P10:54 P10:55 P10:56 P10:57 P10:58 P10:59 P11 P11:60 P11:61 P11:62 P11:63 P11:64 P11:65 P12:66 P12:67 P12:68 P12:69 P12:70 P12:71 P1:0 P1:1 P1:2 P1:3 P1:4 P1:5 P2 P2:10 P2:11 P2:6 P2:7 P2:8 P2:9 P3 P3:12 P3:13 P3:14 P3:15 P3:16 P3:17 P4 P4:18 P4:19 P4:20 P4:21 P4:22 P4:23 P5 P5:24 P5:25 P5:26 P5:27 P5:28 P5:29 P6 P6:30 P6:31 P6:32 P6:33 P6:34 P6:35 P7 P7:36 P7:37 P7:38 P7:39 P7:40 P7:41 P8 P8:42 P8:43 P8:44 P8:45 P8:46 P8:47 P9 P9:48 P9:49 P9:50 P9:51 P9:52 P9:53
CPEX1 P10:56 P12 3.279299724e-01pF
CPEX2 P10:59 P12 4.557314475e-02pF
CPEX3 P11:62 P12 3.279299724e-01pF
CPEX4 P11:65 P12 4.557314475e-02pF
CPEX5 P12:68 P12 3.279299724e-01pF
CPEX6 P12:71 P12 4.557314475e-02pF
CPEX7 P1:2 P12 3.279299724e-01pF
CPEX8 P1:5 P12 4.557314475e-02pF
CPEX9 P2:11 P12 4.557314475e-02pF
CPEX10 P2:8 P12 3.279299724e-01pF
CPEX11 P3:14 P12 3.279299724e-01pF
CPEX12 P3:17 P12 4.557314475e-02pF
CPEX13 P4:20 P12 3.279299724e-01pF
CPEX14 P4:23 P12 4.557314475e-02pF
CPEX15 P5:26 P12 3.279299724e-01pF
CPEX16 P5:29 P12 4.557314475e-02pF
CPEX17 P6:32 P12 3.279299724e-01pF
CPEX18 P6:35 P12 4.557314475e-02pF
CPEX19 P7:38 P12 3.279299724e-01pF
CPEX20 P7:41 P12 4.557314475e-02pF
CPEX21 P8:44 P12 3.279299724e-01pF
CPEX22 P8:47 P12 4.557314475e-02pF
CPEX23 P9:50 P12 3.279299724e-01pF
CPEX24 P9:53 P12 4.557314475e-02pF
CPEX25 P10:54 P5:24 1.56384pF
CPEX26 P10:54 P6:30 1.56384pF
CPEX27 P10:56 P11:62 0.18389688pF
CPEX28 P10:56 P11:65 1.134e-06pF
CPEX29 P10:56 P12:68 0.18269688pF
CPEX30 P10:56 P12:71 1.134e-06pF
CPEX31 P10:56 P1:2 0.17429688pF
CPEX32 P10:56 P2:8 0.17549688pF
CPEX33 P10:56 P3:14 0.17669688pF
CPEX34 P10:56 P4:20 0.17789688pF
CPEX35 P10:56 P5:26 0.17909688pF
CPEX36 P10:56 P6:32 0.18029688pF
CPEX37 P10:56 P7:38 0.18149688pF
CPEX38 P10:56 P8:44 0.18269688pF
CPEX39 P10:56 P9:50 0.18389688pF
CPEX40 P10:59 P1:2 1.134e-06pF
CPEX41 P10:59 P2:8 1.134e-06pF
CPEX42 P10:59 P3:14 1.134e-06pF
CPEX43 P10:59 P4:20 1.134e-06pF
CPEX44 P10:59 P5:26 1.134e-06pF
CPEX45 P10:59 P6:32 1.134e-06pF
CPEX46 P10:59 P7:38 1.134e-06pF
CPEX47 P10:59 P8:44 1.134e-06pF
CPEX48 P10:59 P9:50 1.134e-06pF
CPEX49 P11:60 P6:30 1.56384pF
CPEX50 P11:60 P8:42 1.56384pF
CPEX51 P11:62 P12:68 0.18389688pF
CPEX52 P11:62 P12:71 1.134e-06pF
CPEX53 P11:62 P1:2 0.17309688pF
CPEX54 P11:62 P2:8 0.17429688pF
CPEX55 P11:62 P3:14 0.17549688pF
CPEX56 P11:62 P4:20 0.17669688pF
CPEX57 P11:62 P5:26 0.17789688pF
CPEX58 P11:62 P6:32 0.17909688pF
CPEX59 P11:62 P7:38 0.18029688pF
CPEX60 P11:62 P8:44 0.18149688pF
CPEX61 P11:62 P9:50 0.18269688pF
CPEX62 P11:65 P1:2 1.134e-06pF
CPEX63 P11:65 P2:8 1.134e-06pF
CPEX64 P11:65 P3:14 1.134e-06pF
CPEX65 P11:65 P4:20 1.134e-06pF
CPEX66 P11:65 P5:26 1.134e-06pF
CPEX67 P11:65 P6:32 1.134e-06pF
CPEX68 P11:65 P7:38 1.134e-06pF
CPEX69 P11:65 P8:44 1.134e-06pF
CPEX70 P11:65 P9:50 1.134e-06pF
CPEX71 P12:66 P4:18 0.14544pF
CPEX72 P12:66 P5:24 0.65448pF
CPEX73 P12:66 P8:42 0.29088pF
CPEX74 P12:68 P1:2 0.17189688pF
CPEX75 P12:68 P2:8 0.17309688pF
CPEX76 P12:68 P3:14 0.17429688pF
CPEX77 P12:68 P4:20 0.17549688pF
CPEX78 P12:68 P5:26 0.17669688pF
CPEX79 P12:68 P6:32 0.17789688pF
CPEX80 P12:68 P7:38 0.17909688pF
CPEX81 P12:68 P8:44 0.18029688pF
CPEX82 P12:68 P9:50 0.18149688pF
CPEX83 P12:71 P1:2 1.134e-06pF
CPEX84 P12:71 P2:8 1.134e-06pF
CPEX85 P12:71 P3:14 1.134e-06pF
CPEX86 P12:71 P4:20 1.134e-06pF
CPEX87 P12:71 P5:26 1.134e-06pF
CPEX88 P12:71 P6:32 1.134e-06pF
CPEX89 P12:71 P7:38 1.134e-06pF
CPEX90 P12:71 P8:44 1.134e-06pF
CPEX91 P12:71 P9:50 1.134e-06pF
CPEX92 P1:0 P3:12 0.26064pF
CPEX93 P1:0 P6:30 0.52128pF
CPEX94 P1:0 P7:36 1.17288pF
CPEX95 P1:0 P9:48 2.15028pF
CPEX96 P1:2 P2:11 1.134e-06pF
CPEX97 P1:2 P2:8 0.18389688pF
CPEX98 P1:2 P3:14 0.18269688pF
CPEX99 P1:2 P3:17 1.134e-06pF
CPEX100 P1:2 P4:20 0.18149688pF
CPEX101 P1:2 P4:23 1.134e-06pF
CPEX102 P1:2 P5:26 0.18029688pF
CPEX103 P1:2 P5:29 1.134e-06pF
CPEX104 P1:2 P6:32 0.17909688pF
CPEX105 P1:2 P6:35 1.134e-06pF
CPEX106 P1:2 P7:38 0.17789688pF
CPEX107 P1:2 P7:41 1.134e-06pF
CPEX108 P1:2 P8:44 0.17669688pF
CPEX109 P1:2 P8:47 1.134e-06pF
CPEX110 P1:2 P9:50 0.17549688pF
CPEX111 P1:2 P9:53 1.134e-06pF
CPEX112 P2:10 P3:12 0.07272pF
CPEX113 P2:8 P3:14 0.18389688pF
CPEX114 P2:8 P3:17 1.134e-06pF
CPEX115 P2:8 P4:20 0.18269688pF
CPEX116 P2:8 P4:23 1.134e-06pF
CPEX117 P2:8 P5:26 0.18149688pF
CPEX118 P2:8 P5:29 1.134e-06pF
CPEX119 P2:8 P6:32 0.18029688pF
CPEX120 P2:8 P6:35 1.134e-06pF
CPEX121 P2:8 P7:38 0.17909688pF
CPEX122 P2:8 P7:41 1.134e-06pF
CPEX123 P2:8 P8:44 0.17789688pF
CPEX124 P2:8 P8:47 1.134e-06pF
CPEX125 P2:8 P9:50 0.17669688pF
CPEX126 P2:8 P9:53 1.134e-06pF
CPEX127 P3:12 P4:18 0.14544pF
CPEX128 P3:12 P5:24 0.07272pF
CPEX129 P3:14 P4:20 0.18389688pF
CPEX130 P3:14 P4:23 1.134e-06pF
CPEX131 P3:14 P5:26 0.18269688pF
CPEX132 P3:14 P5:29 1.134e-06pF
CPEX133 P3:14 P6:32 0.18149688pF
CPEX134 P3:14 P6:35 1.134e-06pF
CPEX135 P3:14 P7:38 0.18029688pF
CPEX136 P3:14 P7:41 1.134e-06pF
CPEX137 P3:14 P8:44 0.17909688pF
CPEX138 P3:14 P8:47 1.134e-06pF
CPEX139 P3:14 P9:50 0.17789688pF
CPEX140 P3:14 P9:53 1.134e-06pF
CPEX141 P4:20 P5:26 0.18389688pF
CPEX142 P4:20 P5:29 1.134e-06pF
CPEX143 P4:20 P6:32 0.18269688pF
CPEX144 P4:20 P6:35 1.134e-06pF
CPEX145 P4:20 P7:38 0.18149688pF
CPEX146 P4:20 P7:41 1.134e-06pF
CPEX147 P4:20 P8:44 0.18029688pF
CPEX148 P4:20 P8:47 1.134e-06pF
CPEX149 P4:20 P9:50 0.17909688pF
CPEX150 P4:20 P9:53 1.134e-06pF
CPEX151 P5:24 P7:36 0.65448pF
CPEX152 P5:24 P8:42 0.14544pF
CPEX153 P5:26 P6:32 0.18389688pF
CPEX154 P5:26 P6:35 1.134e-06pF
CPEX155 P5:26 P7:38 0.18269688pF
CPEX156 P5:26 P7:41 1.134e-06pF
CPEX157 P5:26 P8:44 0.18149688pF
CPEX158 P5:26 P8:47 1.134e-06pF
CPEX159 P5:26 P9:50 0.18029688pF
CPEX160 P5:26 P9:53 1.134e-06pF
CPEX161 P6:32 P7:38 0.18389688pF
CPEX162 P6:32 P7:41 1.134e-06pF
CPEX163 P6:32 P8:44 0.18269688pF
CPEX164 P6:32 P8:47 1.134e-06pF
CPEX165 P6:32 P9:50 0.18149688pF
CPEX166 P6:32 P9:53 1.134e-06pF
CPEX167 P7:38 P8:44 0.18389688pF
CPEX168 P7:38 P8:47 1.134e-06pF
CPEX169 P7:38 P9:50 0.18269688pF
CPEX170 P7:38 P9:53 1.134e-06pF
CPEX171 P8:44 P9:50 0.18389688pF
CPEX172 P8:44 P9:53 1.134e-06pF
RPEX173 P1:0 P1:2 4.284650000e+02
RPEX174 P1:2 P1:1 4.284650000e+02
RPEX175 P1:3 P1:5 2.164995000e+01
RPEX176 P1:5 P1:4 2.164995000e+01
RPEX177 P2:6 P2:8 4.284650000e+02
RPEX178 P2:8 P2:7 4.284650000e+02
RPEX179 P2:9 P2:11 2.164995000e+01
RPEX180 P2:11 P2:10 2.164995000e+01
RPEX181 P3:12 P3:14 4.284650000e+02
RPEX182 P3:14 P3:13 4.284650000e+02
RPEX183 P3:15 P3:17 2.164995000e+01
RPEX184 P3:17 P3:16 2.164995000e+01
RPEX185 P4:18 P4:20 4.284650000e+02
RPEX186 P4:20 P4:19 4.284650000e+02
RPEX187 P4:21 P4:23 2.164995000e+01
RPEX188 P4:23 P4:22 2.164995000e+01
RPEX189 P5:24 P5:26 4.284650000e+02
RPEX190 P5:26 P5:25 4.284650000e+02
RPEX191 P5:27 P5:29 2.164995000e+01
RPEX192 P5:29 P5:28 2.164995000e+01
RPEX193 P6:30 P6:32 4.284650000e+02
RPEX194 P6:32 P6:31 4.284650000e+02
RPEX195 P6:33 P6:35 2.164995000e+01
RPEX196 P6:35 P6:34 2.164995000e+01
RPEX197 P7:36 P7:38 4.284650000e+02
RPEX198 P7:38 P7:37 4.284650000e+02
RPEX199 P7:39 P7:41 2.164995000e+01
RPEX200 P7:41 P7:40 2.164995000e+01
RPEX201 P8:42 P8:44 4.284650000e+02
RPEX202 P8:44 P8:43 4.284650000e+02
RPEX203 P8:45 P8:47 2.164995000e+01
RPEX204 P8:47 P8:46 2.164995000e+01
RPEX205 P9:48 P9:50 4.284650000e+02
RPEX206 P9:50 P9:49 4.284650000e+02
RPEX207 P9:51 P9:53 2.164995000e+01
RPEX208 P9:53 P9:52 2.164995000e+01
RPEX209 P10:54 P10:56 4.284650000e+02
RPEX210 P10:56 P10:55 4.284650000e+02
RPEX211 P10:57 P10:59 2.164995000e+01
RPEX212 P10:59 P10:58 2.164995000e+01
RPEX213 P11:60 P11:62 4.284650000e+02
RPEX214 P11:62 P11:61 4.284650000e+02
RPEX215 P11:63 P11:65 2.164995000e+01
RPEX216 P11:65 P11:64 2.164995000e+01
RPEX217 P12:66 P12:68 4.284650000e+02
RPEX218 P12:68 P12:67 4.284650000e+02
RPEX219 P12:69 P12:71 2.164995000e+01
RPEX220 P12:71 P12:70 2.164995000e+01
RPEX221 P1:0 P1:3 1.000000000e+00
RPEX222 P2:6 P2:9 1.000000000e+00
RPEX223 P3:12 P3:15 1.000000000e+00
RPEX224 P4:18 P4:21 1.000000000e+00
RPEX225 P5:24 P5:27 1.000000000e+00
RPEX226 P6:30 P6:33 1.000000000e+00
RPEX227 P7:36 P7:39 1.000000000e+00
RPEX228 P8:42 P8:45 1.000000000e+00
RPEX229 P9:48 P9:51 1.000000000e+00
RPEX230 P10:54 P10:57 1.000000000e+00
RPEX231 P11:60 P11:63 1.000000000e+00
RPEX232 P12:66 P12:69 1.000000000e+00
RPEX233 P1 P1:3 1.000000000e-03
RPEX234 P2 P2:6 1.000000000e-03
RPEX235 P3 P3:15 1.000000000e-03
RPEX236 P4 P4:18 1.000000000e-03
RPEX237 P5 P5:27 1.000000000e-03
RPEX238 P6 P6:33 1.000000000e-03
RPEX239 P7 P7:36 1.000000000e-03
RPEX240 P8 P8:45 1.000000000e-03
RPEX241 P9 P9:51 1.000000000e-03
RPEX242 P10 P10:57 1.000000000e-03
RPEX243 P11 P11:60 1.000000000e-03
RPEX244 P12 P12:69 1.000000000e-03
.ENDS tr1um_parasitics
