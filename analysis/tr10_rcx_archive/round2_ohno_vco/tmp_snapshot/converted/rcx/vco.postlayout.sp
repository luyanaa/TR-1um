* TR-1um engineering post-layout SPICE merge.
* Device hierarchy is from KLayout GDS extraction; distributed RC is from the PEX sidecar.
* Status and unresolved mappings are recorded in the adjacent PEX manifest.
.include "/Users/yanlu/Documents/TR-1um/libs.tech/spice/models/ip62_models_calibrated"
* Begin device hierarchy: /private/tmp/tr10-rcx/converted/rcx/vco.devices.sp
* Created by mapped OpenRule1um bridge

* cell VCO
.SUBCKT VCO P19 P28 P29 P1 P30
* net 1 GND
* net 19 Vout
* net 28 VDD
* net 29 VDD
* net 30 VSS
* device instance $1 r0 *1 205.3,84.1 PMOS
X$1 P28 P22 P22 P29 PMOS L=10U W=6U AS=12P AD=6P PS=16U PD=8U
* device instance $2 r0 *1 217.3,84.1 PMOS
X$2 P22 P22 P28 P29 PMOS L=10U W=6U AS=6P AD=12P PS=8U PD=16U
* device instance $3 r0 *1 476.3,83.1 PMOS
X$3 P27 P22 P28 P29 PMOS L=5U W=3U AS=6P AD=3P PS=10U PD=5U
* device instance $4 r0 *1 483.3,83.1 PMOS
X$4 P28 P22 P27 P29 PMOS L=5U W=3U AS=3P AD=3P PS=5U PD=5U
* device instance $5 r0 *1 490.3,83.1 PMOS
X$5 P27 P22 P28 P29 PMOS L=5U W=3U AS=3P AD=3P PS=5U PD=5U
* device instance $6 r0 *1 497.3,83.1 PMOS
X$6 P28 P22 P27 P29 PMOS L=5U W=3U AS=3P AD=6P PS=5U PD=10U
* device instance $7 r0 *1 437.3,83.1 PMOS
X$7 P26 P22 P28 P29 PMOS L=5U W=3U AS=6P AD=3P PS=10U PD=5U
* device instance $8 r0 *1 444.3,83.1 PMOS
X$8 P28 P22 P26 P29 PMOS L=5U W=3U AS=3P AD=3P PS=5U PD=5U
* device instance $9 r0 *1 451.3,83.1 PMOS
X$9 P26 P22 P28 P29 PMOS L=5U W=3U AS=3P AD=3P PS=5U PD=5U
* device instance $10 r0 *1 458.3,83.1 PMOS
X$10 P28 P22 P26 P29 PMOS L=5U W=3U AS=3P AD=6P PS=5U PD=10U
* device instance $11 r0 *1 398.3,83.1 PMOS
X$11 P21 P22 P28 P29 PMOS L=5U W=3U AS=6P AD=3P PS=10U PD=5U
* device instance $12 r0 *1 405.3,83.1 PMOS
X$12 P28 P22 P21 P29 PMOS L=5U W=3U AS=3P AD=3P PS=5U PD=5U
* device instance $13 r0 *1 412.3,83.1 PMOS
X$13 P21 P22 P28 P29 PMOS L=5U W=3U AS=3P AD=3P PS=5U PD=5U
* device instance $14 r0 *1 419.3,83.1 PMOS
X$14 P28 P22 P21 P29 PMOS L=5U W=3U AS=3P AD=6P PS=5U PD=10U
* device instance $15 r0 *1 320.3,83.1 PMOS
X$15 P24 P22 P28 P29 PMOS L=5U W=3U AS=6P AD=3P PS=10U PD=5U
* device instance $16 r0 *1 327.3,83.1 PMOS
X$16 P28 P22 P24 P29 PMOS L=5U W=3U AS=3P AD=3P PS=5U PD=5U
* device instance $17 r0 *1 334.3,83.1 PMOS
X$17 P24 P22 P28 P29 PMOS L=5U W=3U AS=3P AD=3P PS=5U PD=5U
* device instance $18 r0 *1 341.3,83.1 PMOS
X$18 P28 P22 P24 P29 PMOS L=5U W=3U AS=3P AD=6P PS=5U PD=10U
* device instance $19 r0 *1 332.4,66.1 PMOS
X$19 P4 P3 P24 P29 PMOS L=1U W=3U AS=6P AD=6P PS=10U PD=10U
* device instance $20 r0 *1 281.3,83.1 PMOS
X$20 P23 P22 P28 P29 PMOS L=5U W=3U AS=6P AD=3P PS=10U PD=5U
* device instance $21 r0 *1 288.3,83.1 PMOS
X$21 P28 P22 P23 P29 PMOS L=5U W=3U AS=3P AD=3P PS=5U PD=5U
* device instance $22 r0 *1 295.3,83.1 PMOS
X$22 P23 P22 P28 P29 PMOS L=5U W=3U AS=3P AD=3P PS=5U PD=5U
* device instance $23 r0 *1 302.3,83.1 PMOS
X$23 P28 P22 P23 P29 PMOS L=5U W=3U AS=3P AD=6P PS=5U PD=10U
* device instance $24 r0 *1 359.3,83.1 PMOS
X$24 P25 P22 P28 P29 PMOS L=5U W=3U AS=6P AD=3P PS=10U PD=5U
* device instance $25 r0 *1 366.3,83.1 PMOS
X$25 P28 P22 P25 P29 PMOS L=5U W=3U AS=3P AD=3P PS=5U PD=5U
* device instance $26 r0 *1 373.3,83.1 PMOS
X$26 P25 P22 P28 P29 PMOS L=5U W=3U AS=3P AD=3P PS=5U PD=5U
* device instance $27 r0 *1 380.3,83.1 PMOS
X$27 P28 P22 P25 P29 PMOS L=5U W=3U AS=3P AD=6P PS=5U PD=10U
* device instance $28 r0 *1 530.5,66.1 PMOS
X$28 P19 P18 P28 P29 PMOS L=1U W=3U AS=6P AD=6P PS=10U PD=10U
* device instance $29 r0 *1 242.3,83.1 PMOS
X$29 P20 P22 P28 P29 PMOS L=5U W=3U AS=6P AD=3P PS=10U PD=5U
* device instance $30 r0 *1 249.3,83.1 PMOS
X$30 P28 P22 P20 P29 PMOS L=5U W=3U AS=3P AD=3P PS=5U PD=5U
* device instance $31 r0 *1 256.3,83.1 PMOS
X$31 P20 P22 P28 P29 PMOS L=5U W=3U AS=3P AD=3P PS=5U PD=5U
* device instance $32 r0 *1 263.3,83.1 PMOS
X$32 P28 P22 P20 P29 PMOS L=5U W=3U AS=3P AD=6P PS=5U PD=10U
* device instance $33 r0 *1 516.5,66.1 PMOS
X$33 P18 P8 P28 P29 PMOS L=1U W=3U AS=6P AD=6P PS=10U PD=10U
* device instance $34 r0 *1 449.4,66.1 PMOS
X$34 P7 P6 P26 P29 PMOS L=1U W=3U AS=6P AD=6P PS=10U PD=10U
* device instance $35 r0 *1 410.4,66.1 PMOS
X$35 P6 P5 P21 P29 PMOS L=1U W=3U AS=6P AD=6P PS=10U PD=10U
* device instance $36 r0 *1 371.4,66.1 PMOS
X$36 P5 P4 P25 P29 PMOS L=1U W=3U AS=6P AD=6P PS=10U PD=10U
* device instance $37 r0 *1 488.4,66.1 PMOS
X$37 P8 P7 P27 P29 PMOS L=1U W=3U AS=6P AD=6P PS=10U PD=10U
* device instance $38 r0 *1 254.4,66.1 PMOS
X$38 P2 P8 P20 P29 PMOS L=1U W=3U AS=6P AD=6P PS=10U PD=10U
* device instance $39 r0 *1 293.4,66.1 PMOS
X$39 P3 P2 P23 P29 PMOS L=1U W=3U AS=6P AD=6P PS=10U PD=10U
* device instance $40 r0 *1 205.4,40.9 NMOS
X$40 P9 P17 P1 P30 NMOS L=10U W=2U AS=4P AD=2P PS=8U PD=4U
* device instance $41 r0 *1 217.4,40.9 NMOS
X$41 P1 P17 P9 P30 NMOS L=10U W=2U AS=2P AD=4P PS=4U PD=8U
* device instance $42 r0 *1 242.2,41.6 NMOS
X$42 P10 P17 P1 P30 NMOS L=5U W=2U AS=4P AD=2P PS=8U PD=4U
* device instance $43 r0 *1 249.2,41.6 NMOS
X$43 P1 P17 P10 P30 NMOS L=5U W=2U AS=2P AD=2P PS=4U PD=4U
* device instance $44 r0 *1 256.2,41.6 NMOS
X$44 P10 P17 P1 P30 NMOS L=5U W=2U AS=2P AD=2P PS=4U PD=4U
* device instance $45 r0 *1 263.2,41.6 NMOS
X$45 P1 P17 P10 P30 NMOS L=5U W=2U AS=2P AD=4P PS=4U PD=8U
* device instance $46 r0 *1 281.2,41.6 NMOS
X$46 P11 P17 P1 P30 NMOS L=5U W=2U AS=4P AD=2P PS=8U PD=4U
* device instance $47 r0 *1 288.2,41.6 NMOS
X$47 P1 P17 P11 P30 NMOS L=5U W=2U AS=2P AD=2P PS=4U PD=4U
* device instance $48 r0 *1 295.2,41.6 NMOS
X$48 P11 P17 P1 P30 NMOS L=5U W=2U AS=2P AD=2P PS=4U PD=4U
* device instance $49 r0 *1 302.2,41.6 NMOS
X$49 P1 P17 P11 P30 NMOS L=5U W=2U AS=2P AD=4P PS=4U PD=8U
* device instance $50 r0 *1 320.2,41.6 NMOS
X$50 P12 P17 P1 P30 NMOS L=5U W=2U AS=4P AD=2P PS=8U PD=4U
* device instance $51 r0 *1 327.2,41.6 NMOS
X$51 P1 P17 P12 P30 NMOS L=5U W=2U AS=2P AD=2P PS=4U PD=4U
* device instance $52 r0 *1 334.2,41.6 NMOS
X$52 P12 P17 P1 P30 NMOS L=5U W=2U AS=2P AD=2P PS=4U PD=4U
* device instance $53 r0 *1 341.2,41.6 NMOS
X$53 P1 P17 P12 P30 NMOS L=5U W=2U AS=2P AD=4P PS=4U PD=8U
* device instance $54 r0 *1 359.2,41.6 NMOS
X$54 P13 P17 P1 P30 NMOS L=5U W=2U AS=4P AD=2P PS=8U PD=4U
* device instance $55 r0 *1 366.2,41.6 NMOS
X$55 P1 P17 P13 P30 NMOS L=5U W=2U AS=2P AD=2P PS=4U PD=4U
* device instance $56 r0 *1 373.2,41.6 NMOS
X$56 P13 P17 P1 P30 NMOS L=5U W=2U AS=2P AD=2P PS=4U PD=4U
* device instance $57 r0 *1 380.2,41.6 NMOS
X$57 P1 P17 P13 P30 NMOS L=5U W=2U AS=2P AD=4P PS=4U PD=8U
* device instance $58 r0 *1 398.2,41.6 NMOS
X$58 P14 P17 P1 P30 NMOS L=5U W=2U AS=4P AD=2P PS=8U PD=4U
* device instance $59 r0 *1 405.2,41.6 NMOS
X$59 P1 P17 P14 P30 NMOS L=5U W=2U AS=2P AD=2P PS=4U PD=4U
* device instance $60 r0 *1 412.2,41.6 NMOS
X$60 P14 P17 P1 P30 NMOS L=5U W=2U AS=2P AD=2P PS=4U PD=4U
* device instance $61 r0 *1 419.2,41.6 NMOS
X$61 P1 P17 P14 P30 NMOS L=5U W=2U AS=2P AD=4P PS=4U PD=8U
* device instance $62 r0 *1 437.2,41.6 NMOS
X$62 P15 P17 P1 P30 NMOS L=5U W=2U AS=4P AD=2P PS=8U PD=4U
* device instance $63 r0 *1 444.2,41.6 NMOS
X$63 P1 P17 P15 P30 NMOS L=5U W=2U AS=2P AD=2P PS=4U PD=4U
* device instance $64 r0 *1 451.2,41.6 NMOS
X$64 P15 P17 P1 P30 NMOS L=5U W=2U AS=2P AD=2P PS=4U PD=4U
* device instance $65 r0 *1 458.2,41.6 NMOS
X$65 P1 P17 P15 P30 NMOS L=5U W=2U AS=2P AD=4P PS=4U PD=8U
* device instance $66 r0 *1 476.2,41.6 NMOS
X$66 P16 P17 P1 P30 NMOS L=5U W=2U AS=4P AD=2P PS=8U PD=4U
* device instance $67 r0 *1 483.2,41.6 NMOS
X$67 P1 P17 P16 P30 NMOS L=5U W=2U AS=2P AD=2P PS=4U PD=4U
* device instance $68 r0 *1 490.2,41.6 NMOS
X$68 P16 P17 P1 P30 NMOS L=5U W=2U AS=2P AD=2P PS=4U PD=4U
* device instance $69 r0 *1 497.2,41.6 NMOS
X$69 P1 P17 P16 P30 NMOS L=5U W=2U AS=2P AD=4P PS=4U PD=8U
* device instance $70 r0 *1 205.3,63.2 NMOS
X$70 P22 P22 P9 P30 NMOS L=10U W=2U AS=4P AD=2P PS=8U PD=4U
* device instance $71 r0 *1 217.3,63.2 NMOS
X$71 P9 P22 P22 P30 NMOS L=10U W=2U AS=2P AD=4P PS=4U PD=8U
* device instance $72 r0 *1 254.4,54.6 NMOS
X$72 P2 P8 P10 P30 NMOS L=1U W=2U AS=4P AD=4P PS=8U PD=8U
* device instance $73 r0 *1 293.4,54.6 NMOS
X$73 P3 P2 P11 P30 NMOS L=1U W=2U AS=4P AD=4P PS=8U PD=8U
* device instance $74 r0 *1 332.4,54.6 NMOS
X$74 P4 P3 P12 P30 NMOS L=1U W=2U AS=4P AD=4P PS=8U PD=8U
* device instance $75 r0 *1 371.4,54.6 NMOS
X$75 P5 P4 P13 P30 NMOS L=1U W=2U AS=4P AD=4P PS=8U PD=8U
* device instance $76 r0 *1 410.4,54.6 NMOS
X$76 P6 P5 P14 P30 NMOS L=1U W=2U AS=4P AD=4P PS=8U PD=8U
* device instance $77 r0 *1 449.4,54.6 NMOS
X$77 P7 P6 P15 P30 NMOS L=1U W=2U AS=4P AD=4P PS=8U PD=8U
* device instance $78 r0 *1 488.4,54.6 NMOS
X$78 P8 P7 P16 P30 NMOS L=1U W=2U AS=4P AD=4P PS=8U PD=8U
* device instance $79 r0 *1 516.5,54.6 NMOS
X$79 P18 P8 P1 P30 NMOS L=1U W=2U AS=4P AD=4P PS=8U PD=8U
* device instance $80 r0 *1 530.5,54.6 NMOS
X$80 P19 P18 P1 P30 NMOS L=1U W=2U AS=4P AD=4P PS=8U PD=8U
* Legacy OpenRule1um poly-cap markers retained as explicit simulation caps.
CLEG1 P2 P1 1.224e-12
CLEG2 P3 P1 1.224e-12
CLEG3 P4 P1 1.224e-12
CLEG4 P5 P1 1.224e-12
CLEG5 P6 P1 1.224e-12
CLEG6 P7 P1 1.224e-12
CLEG7 P8 P1 1.224e-12
* Distributed RC ownership: wire/via/coupling network from the PEX sidecar.
XPEX_TR1UM P1 P10 P10:54 P10:55 P10:56 P10:57 P10:58 P10:59 P11 P11:60 P11:61 P11:62 P11:63 P11:64 P11:65 P12 P12:66 P12:67 P12:68 P12:69 P12:70 P12:71 P13 P13:72 P13:73 P13:74 P13:75 P13:76 P13:77 P14 P14:78 P14:79 P14:80 P14:81 P14:82 P14:83 P15 P15:84 P15:85 P15:86 P15:87 P15:88 P15:89 P16 P16:90 P16:91 P16:92 P16:93 P16:94 P16:95 P17 P17:100 P17:101 P17:96 P17:97 P17:98 P17:99 P18 P18:102 P18:103 P18:104 P18:105 P18:106 P18:107 P19 P19:108 P19:109 P19:110 P19:111 P19:112 P19:113 P1:0 P1:1 P1:2 P1:3 P1:4 P1:5 P2 P20 P20:114 P20:115 P20:116 P20:117 P20:118 P20:119 P21 P21:120 P21:121 P21:122 P21:123 P21:124 P21:125 P22 P22:126 P22:127 P22:128 P22:129 P22:130 P22:131 P23 P23:132 P23:133 P23:134 P23:135 P23:136 P23:137 P24 P24:138 P24:139 P24:140 P24:141 P24:142 P24:143 P25 P25:144 P25:145 P25:146 P25:147 P25:148 P25:149 P26 P26:150 P26:151 P26:152 P26:153 P26:154 P26:155 P27 P27:156 P27:157 P27:158 P27:159 P27:160 P27:161 P28 P28:162 P28:163 P28:164 P28:165 P28:166 P28:167 P29 P29:168 P29:169 P29:170 P29:171 P29:172 P29:173 P2:10 P2:11 P2:6 P2:7 P2:8 P2:9 P3 P30 P30:174 P30:175 P30:176 P30:177 P30:178 P30:179 P3:12 P3:13 P3:14 P3:15 P3:16 P3:17 P4 P4:18 P4:19 P4:20 P4:21 P4:22 P4:23 P5 P5:24 P5:25 P5:26 P5:27 P5:28 P5:29 P6 P6:30 P6:31 P6:32 P6:33 P6:34 P6:35 P7 P7:36 P7:37 P7:38 P7:39 P7:40 P7:41 P8 P8:42 P8:43 P8:44 P8:45 P8:46 P8:47 P9 P9:48 P9:49 P9:50 P9:51 P9:52 P9:53 tr1um_parasitics
.ENDS VCO
* Begin distributed interconnect: /private/tmp/tr10-rcx/converted/rcx/vco.pex.sp
* TR-1um engineering distributed parasitic RC network.
* Include this subcircuit only when its device-cap ownership is understood.
.SUBCKT tr1um_parasitics P1 P10 P10:54 P10:55 P10:56 P10:57 P10:58 P10:59 P11 P11:60 P11:61 P11:62 P11:63 P11:64 P11:65 P12 P12:66 P12:67 P12:68 P12:69 P12:70 P12:71 P13 P13:72 P13:73 P13:74 P13:75 P13:76 P13:77 P14 P14:78 P14:79 P14:80 P14:81 P14:82 P14:83 P15 P15:84 P15:85 P15:86 P15:87 P15:88 P15:89 P16 P16:90 P16:91 P16:92 P16:93 P16:94 P16:95 P17 P17:100 P17:101 P17:96 P17:97 P17:98 P17:99 P18 P18:102 P18:103 P18:104 P18:105 P18:106 P18:107 P19 P19:108 P19:109 P19:110 P19:111 P19:112 P19:113 P1:0 P1:1 P1:2 P1:3 P1:4 P1:5 P2 P20 P20:114 P20:115 P20:116 P20:117 P20:118 P20:119 P21 P21:120 P21:121 P21:122 P21:123 P21:124 P21:125 P22 P22:126 P22:127 P22:128 P22:129 P22:130 P22:131 P23 P23:132 P23:133 P23:134 P23:135 P23:136 P23:137 P24 P24:138 P24:139 P24:140 P24:141 P24:142 P24:143 P25 P25:144 P25:145 P25:146 P25:147 P25:148 P25:149 P26 P26:150 P26:151 P26:152 P26:153 P26:154 P26:155 P27 P27:156 P27:157 P27:158 P27:159 P27:160 P27:161 P28 P28:162 P28:163 P28:164 P28:165 P28:166 P28:167 P29 P29:168 P29:169 P29:170 P29:171 P29:172 P29:173 P2:10 P2:11 P2:6 P2:7 P2:8 P2:9 P3 P30 P30:174 P30:175 P30:176 P30:177 P30:178 P30:179 P3:12 P3:13 P3:14 P3:15 P3:16 P3:17 P4 P4:18 P4:19 P4:20 P4:21 P4:22 P4:23 P5 P5:24 P5:25 P5:26 P5:27 P5:28 P5:29 P6 P6:30 P6:31 P6:32 P6:33 P6:34 P6:35 P7 P7:36 P7:37 P7:38 P7:39 P7:40 P7:41 P8 P8:42 P8:43 P8:44 P8:45 P8:46 P8:47 P9 P9:48 P9:49 P9:50 P9:51 P9:52 P9:53
CPEX1 P10:56 P1 2.356256430e-02pF
CPEX2 P10:59 P1 2.533683250e-03pF
CPEX3 P11:62 P1 2.356256430e-02pF
CPEX4 P11:65 P1 2.533683250e-03pF
CPEX5 P12:68 P1 2.356256430e-02pF
CPEX6 P12:71 P1 2.533683250e-03pF
CPEX7 P13:74 P1 2.356256430e-02pF
CPEX8 P13:77 P1 2.533683250e-03pF
CPEX9 P14:80 P1 2.356256430e-02pF
CPEX10 P14:83 P1 2.533683250e-03pF
CPEX11 P15:86 P1 2.356256430e-02pF
CPEX12 P15:89 P1 2.533683250e-03pF
CPEX13 P16:92 P1 2.356256430e-02pF
CPEX14 P16:95 P1 2.533683250e-03pF
CPEX15 P17:101 P1 2.533683250e-03pF
CPEX16 P17:98 P1 2.356256430e-02pF
CPEX17 P18:104 P1 2.356256430e-02pF
CPEX18 P18:107 P1 2.533683250e-03pF
CPEX19 P19:110 P1 2.356256430e-02pF
CPEX20 P19:113 P1 2.533683250e-03pF
CPEX21 P1:2 P1 2.356256430e-02pF
CPEX22 P1:5 P1 2.533683250e-03pF
CPEX23 P20:116 P1 2.356256430e-02pF
CPEX24 P20:119 P1 2.533683250e-03pF
CPEX25 P21:122 P1 2.356256430e-02pF
CPEX26 P21:125 P1 2.533683250e-03pF
CPEX27 P22:128 P1 2.356256430e-02pF
CPEX28 P22:131 P1 2.533683250e-03pF
CPEX29 P23:134 P1 2.356256430e-02pF
CPEX30 P23:137 P1 2.533683250e-03pF
CPEX31 P24:140 P1 2.356256430e-02pF
CPEX32 P24:143 P1 2.533683250e-03pF
CPEX33 P25:146 P1 2.356256430e-02pF
CPEX34 P25:149 P1 2.533683250e-03pF
CPEX35 P26:152 P1 2.356256430e-02pF
CPEX36 P26:155 P1 2.533683250e-03pF
CPEX37 P27:158 P1 2.356256430e-02pF
CPEX38 P27:161 P1 2.533683250e-03pF
CPEX39 P28:164 P1 2.356256430e-02pF
CPEX40 P28:167 P1 2.533683250e-03pF
CPEX41 P29:170 P1 2.356256430e-02pF
CPEX42 P29:173 P1 2.533683250e-03pF
CPEX43 P2:11 P1 2.533683250e-03pF
CPEX44 P2:8 P1 2.356256430e-02pF
CPEX45 P30:176 P1 2.356256430e-02pF
CPEX46 P30:179 P1 2.533683250e-03pF
CPEX47 P3:14 P1 2.356256430e-02pF
CPEX48 P3:17 P1 2.533683250e-03pF
CPEX49 P4:20 P1 2.356256430e-02pF
CPEX50 P4:23 P1 2.533683250e-03pF
CPEX51 P5:26 P1 2.356256430e-02pF
CPEX52 P5:29 P1 2.533683250e-03pF
CPEX53 P6:32 P1 2.356256430e-02pF
CPEX54 P6:35 P1 2.533683250e-03pF
CPEX55 P7:38 P1 2.356256430e-02pF
CPEX56 P7:41 P1 2.533683250e-03pF
CPEX57 P8:44 P1 2.356256430e-02pF
CPEX58 P8:47 P1 2.533683250e-03pF
CPEX59 P9:50 P1 2.356256430e-02pF
CPEX60 P9:53 P1 2.533683250e-03pF
CPEX61 P10:54 P17:100 1.616000000e-02pF
CPEX62 P10:54 P8:42 4.040000000e-03pF
CPEX63 P10:56 P11:62 1.008305000e-02pF
CPEX64 P10:56 P11:65 9.450000000e-07pF
CPEX65 P10:56 P12:68 9.083050000e-03pF
CPEX66 P10:56 P12:71 9.450000000e-07pF
CPEX67 P10:56 P13:74 8.083050000e-03pF
CPEX68 P10:56 P13:77 9.450000000e-07pF
CPEX69 P10:56 P14:80 7.083050000e-03pF
CPEX70 P10:56 P14:83 9.450000000e-07pF
CPEX71 P10:56 P15:86 6.083050000e-03pF
CPEX72 P10:56 P15:89 9.450000000e-07pF
CPEX73 P10:56 P16:92 5.083050000e-03pF
CPEX74 P10:56 P16:95 9.450000000e-07pF
CPEX75 P10:56 P17:101 9.450000000e-07pF
CPEX76 P10:56 P17:98 4.083050000e-03pF
CPEX77 P10:56 P18:104 3.083050000e-03pF
CPEX78 P10:56 P18:107 9.450000000e-07pF
CPEX79 P10:56 P19:110 2.083050000e-03pF
CPEX80 P10:56 P19:113 9.450000000e-07pF
CPEX81 P10:56 P1:2 2.083050000e-03pF
CPEX82 P10:56 P20:116 1.083050000e-03pF
CPEX83 P10:56 P20:119 9.450000000e-07pF
CPEX84 P10:56 P21:122 8.305000000e-05pF
CPEX85 P10:56 P21:125 9.450000000e-07pF
CPEX86 P10:56 P2:8 3.083050000e-03pF
CPEX87 P10:56 P3:14 4.083050000e-03pF
CPEX88 P10:56 P4:20 5.083050000e-03pF
CPEX89 P10:56 P5:26 6.083050000e-03pF
CPEX90 P10:56 P6:32 7.083050000e-03pF
CPEX91 P10:56 P7:38 8.083050000e-03pF
CPEX92 P10:56 P8:44 9.083050000e-03pF
CPEX93 P10:56 P9:50 1.008305000e-02pF
CPEX94 P10:59 P1:2 9.450000000e-07pF
CPEX95 P10:59 P2:8 9.450000000e-07pF
CPEX96 P10:59 P3:14 9.450000000e-07pF
CPEX97 P10:59 P4:20 9.450000000e-07pF
CPEX98 P10:59 P5:26 9.450000000e-07pF
CPEX99 P10:59 P6:32 9.450000000e-07pF
CPEX100 P10:59 P7:38 9.450000000e-07pF
CPEX101 P10:59 P8:44 9.450000000e-07pF
CPEX102 P10:59 P9:50 9.450000000e-07pF
CPEX103 P11:60 P17:100 1.616000000e-02pF
CPEX104 P11:60 P2:10 4.040000000e-03pF
CPEX105 P11:62 P12:68 1.008305000e-02pF
CPEX106 P11:62 P12:71 9.450000000e-07pF
CPEX107 P11:62 P13:74 9.083050000e-03pF
CPEX108 P11:62 P13:77 9.450000000e-07pF
CPEX109 P11:62 P14:80 8.083050000e-03pF
CPEX110 P11:62 P14:83 9.450000000e-07pF
CPEX111 P11:62 P15:86 7.083050000e-03pF
CPEX112 P11:62 P15:89 9.450000000e-07pF
CPEX113 P11:62 P16:92 6.083050000e-03pF
CPEX114 P11:62 P16:95 9.450000000e-07pF
CPEX115 P11:62 P17:101 9.450000000e-07pF
CPEX116 P11:62 P17:98 5.083050000e-03pF
CPEX117 P11:62 P18:104 4.083050000e-03pF
CPEX118 P11:62 P18:107 9.450000000e-07pF
CPEX119 P11:62 P19:110 3.083050000e-03pF
CPEX120 P11:62 P19:113 9.450000000e-07pF
CPEX121 P11:62 P1:2 1.083050000e-03pF
CPEX122 P11:62 P20:116 2.083050000e-03pF
CPEX123 P11:62 P20:119 9.450000000e-07pF
CPEX124 P11:62 P21:122 1.083050000e-03pF
CPEX125 P11:62 P21:125 9.450000000e-07pF
CPEX126 P11:62 P22:128 8.305000000e-05pF
CPEX127 P11:62 P22:131 9.450000000e-07pF
CPEX128 P11:62 P2:8 2.083050000e-03pF
CPEX129 P11:62 P3:14 3.083050000e-03pF
CPEX130 P11:62 P4:20 4.083050000e-03pF
CPEX131 P11:62 P5:26 5.083050000e-03pF
CPEX132 P11:62 P6:32 6.083050000e-03pF
CPEX133 P11:62 P7:38 7.083050000e-03pF
CPEX134 P11:62 P8:44 8.083050000e-03pF
CPEX135 P11:62 P9:50 9.083050000e-03pF
CPEX136 P11:65 P1:2 9.450000000e-07pF
CPEX137 P11:65 P2:8 9.450000000e-07pF
CPEX138 P11:65 P3:14 9.450000000e-07pF
CPEX139 P11:65 P4:20 9.450000000e-07pF
CPEX140 P11:65 P5:26 9.450000000e-07pF
CPEX141 P11:65 P6:32 9.450000000e-07pF
CPEX142 P11:65 P7:38 9.450000000e-07pF
CPEX143 P11:65 P8:44 9.450000000e-07pF
CPEX144 P11:65 P9:50 9.450000000e-07pF
CPEX145 P12:66 P17:100 1.616000000e-02pF
CPEX146 P12:66 P3:12 4.040000000e-03pF
CPEX147 P12:68 P13:74 1.008305000e-02pF
CPEX148 P12:68 P13:77 9.450000000e-07pF
CPEX149 P12:68 P14:80 9.083050000e-03pF
CPEX150 P12:68 P14:83 9.450000000e-07pF
CPEX151 P12:68 P15:86 8.083050000e-03pF
CPEX152 P12:68 P15:89 9.450000000e-07pF
CPEX153 P12:68 P16:92 7.083050000e-03pF
CPEX154 P12:68 P16:95 9.450000000e-07pF
CPEX155 P12:68 P17:101 9.450000000e-07pF
CPEX156 P12:68 P17:98 6.083050000e-03pF
CPEX157 P12:68 P18:104 5.083050000e-03pF
CPEX158 P12:68 P18:107 9.450000000e-07pF
CPEX159 P12:68 P19:110 4.083050000e-03pF
CPEX160 P12:68 P19:113 9.450000000e-07pF
CPEX161 P12:68 P1:2 8.305000000e-05pF
CPEX162 P12:68 P20:116 3.083050000e-03pF
CPEX163 P12:68 P20:119 9.450000000e-07pF
CPEX164 P12:68 P21:122 2.083050000e-03pF
CPEX165 P12:68 P21:125 9.450000000e-07pF
CPEX166 P12:68 P22:128 1.083050000e-03pF
CPEX167 P12:68 P22:131 9.450000000e-07pF
CPEX168 P12:68 P23:134 8.305000000e-05pF
CPEX169 P12:68 P23:137 9.450000000e-07pF
CPEX170 P12:68 P2:8 1.083050000e-03pF
CPEX171 P12:68 P3:14 2.083050000e-03pF
CPEX172 P12:68 P4:20 3.083050000e-03pF
CPEX173 P12:68 P5:26 4.083050000e-03pF
CPEX174 P12:68 P6:32 5.083050000e-03pF
CPEX175 P12:68 P7:38 6.083050000e-03pF
CPEX176 P12:68 P8:44 7.083050000e-03pF
CPEX177 P12:68 P9:50 8.083050000e-03pF
CPEX178 P12:71 P1:2 9.450000000e-07pF
CPEX179 P12:71 P2:8 9.450000000e-07pF
CPEX180 P12:71 P3:14 9.450000000e-07pF
CPEX181 P12:71 P4:20 9.450000000e-07pF
CPEX182 P12:71 P5:26 9.450000000e-07pF
CPEX183 P12:71 P6:32 9.450000000e-07pF
CPEX184 P12:71 P7:38 9.450000000e-07pF
CPEX185 P12:71 P8:44 9.450000000e-07pF
CPEX186 P12:71 P9:50 9.450000000e-07pF
CPEX187 P13:72 P17:100 1.616000000e-02pF
CPEX188 P13:72 P4:18 4.040000000e-03pF
CPEX189 P13:74 P14:80 1.008305000e-02pF
CPEX190 P13:74 P14:83 9.450000000e-07pF
CPEX191 P13:74 P15:86 9.083050000e-03pF
CPEX192 P13:74 P15:89 9.450000000e-07pF
CPEX193 P13:74 P16:92 8.083050000e-03pF
CPEX194 P13:74 P16:95 9.450000000e-07pF
CPEX195 P13:74 P17:101 9.450000000e-07pF
CPEX196 P13:74 P17:98 7.083050000e-03pF
CPEX197 P13:74 P18:104 6.083050000e-03pF
CPEX198 P13:74 P18:107 9.450000000e-07pF
CPEX199 P13:74 P19:110 5.083050000e-03pF
CPEX200 P13:74 P19:113 9.450000000e-07pF
CPEX201 P13:74 P20:116 4.083050000e-03pF
CPEX202 P13:74 P20:119 9.450000000e-07pF
CPEX203 P13:74 P21:122 3.083050000e-03pF
CPEX204 P13:74 P21:125 9.450000000e-07pF
CPEX205 P13:74 P22:128 2.083050000e-03pF
CPEX206 P13:74 P22:131 9.450000000e-07pF
CPEX207 P13:74 P23:134 1.083050000e-03pF
CPEX208 P13:74 P23:137 9.450000000e-07pF
CPEX209 P13:74 P24:140 8.305000000e-05pF
CPEX210 P13:74 P24:143 9.450000000e-07pF
CPEX211 P13:74 P2:8 8.305000000e-05pF
CPEX212 P13:74 P3:14 1.083050000e-03pF
CPEX213 P13:74 P4:20 2.083050000e-03pF
CPEX214 P13:74 P5:26 3.083050000e-03pF
CPEX215 P13:74 P6:32 4.083050000e-03pF
CPEX216 P13:74 P7:38 5.083050000e-03pF
CPEX217 P13:74 P8:44 6.083050000e-03pF
CPEX218 P13:74 P9:50 7.083050000e-03pF
CPEX219 P13:77 P2:8 9.450000000e-07pF
CPEX220 P13:77 P3:14 9.450000000e-07pF
CPEX221 P13:77 P4:20 9.450000000e-07pF
CPEX222 P13:77 P5:26 9.450000000e-07pF
CPEX223 P13:77 P6:32 9.450000000e-07pF
CPEX224 P13:77 P7:38 9.450000000e-07pF
CPEX225 P13:77 P8:44 9.450000000e-07pF
CPEX226 P13:77 P9:50 9.450000000e-07pF
CPEX227 P14:78 P17:100 1.616000000e-02pF
CPEX228 P14:78 P5:24 4.040000000e-03pF
CPEX229 P14:80 P15:86 1.008305000e-02pF
CPEX230 P14:80 P15:89 9.450000000e-07pF
CPEX231 P14:80 P16:92 9.083050000e-03pF
CPEX232 P14:80 P16:95 9.450000000e-07pF
CPEX233 P14:80 P17:101 9.450000000e-07pF
CPEX234 P14:80 P17:98 8.083050000e-03pF
CPEX235 P14:80 P18:104 7.083050000e-03pF
CPEX236 P14:80 P18:107 9.450000000e-07pF
CPEX237 P14:80 P19:110 6.083050000e-03pF
CPEX238 P14:80 P19:113 9.450000000e-07pF
CPEX239 P14:80 P20:116 5.083050000e-03pF
CPEX240 P14:80 P20:119 9.450000000e-07pF
CPEX241 P14:80 P21:122 4.083050000e-03pF
CPEX242 P14:80 P21:125 9.450000000e-07pF
CPEX243 P14:80 P22:128 3.083050000e-03pF
CPEX244 P14:80 P22:131 9.450000000e-07pF
CPEX245 P14:80 P23:134 2.083050000e-03pF
CPEX246 P14:80 P23:137 9.450000000e-07pF
CPEX247 P14:80 P24:140 1.083050000e-03pF
CPEX248 P14:80 P24:143 9.450000000e-07pF
CPEX249 P14:80 P25:146 8.305000000e-05pF
CPEX250 P14:80 P25:149 9.450000000e-07pF
CPEX251 P14:80 P3:14 8.305000000e-05pF
CPEX252 P14:80 P4:20 1.083050000e-03pF
CPEX253 P14:80 P5:26 2.083050000e-03pF
CPEX254 P14:80 P6:32 3.083050000e-03pF
CPEX255 P14:80 P7:38 4.083050000e-03pF
CPEX256 P14:80 P8:44 5.083050000e-03pF
CPEX257 P14:80 P9:50 6.083050000e-03pF
CPEX258 P14:83 P3:14 9.450000000e-07pF
CPEX259 P14:83 P4:20 9.450000000e-07pF
CPEX260 P14:83 P5:26 9.450000000e-07pF
CPEX261 P14:83 P6:32 9.450000000e-07pF
CPEX262 P14:83 P7:38 9.450000000e-07pF
CPEX263 P14:83 P8:44 9.450000000e-07pF
CPEX264 P14:83 P9:50 9.450000000e-07pF
CPEX265 P15:84 P17:100 1.616000000e-02pF
CPEX266 P15:84 P6:30 4.040000000e-03pF
CPEX267 P15:86 P16:92 1.008305000e-02pF
CPEX268 P15:86 P16:95 9.450000000e-07pF
CPEX269 P15:86 P17:101 9.450000000e-07pF
CPEX270 P15:86 P17:98 9.083050000e-03pF
CPEX271 P15:86 P18:104 8.083050000e-03pF
CPEX272 P15:86 P18:107 9.450000000e-07pF
CPEX273 P15:86 P19:110 7.083050000e-03pF
CPEX274 P15:86 P19:113 9.450000000e-07pF
CPEX275 P15:86 P20:116 6.083050000e-03pF
CPEX276 P15:86 P20:119 9.450000000e-07pF
CPEX277 P15:86 P21:122 5.083050000e-03pF
CPEX278 P15:86 P21:125 9.450000000e-07pF
CPEX279 P15:86 P22:128 4.083050000e-03pF
CPEX280 P15:86 P22:131 9.450000000e-07pF
CPEX281 P15:86 P23:134 3.083050000e-03pF
CPEX282 P15:86 P23:137 9.450000000e-07pF
CPEX283 P15:86 P24:140 2.083050000e-03pF
CPEX284 P15:86 P24:143 9.450000000e-07pF
CPEX285 P15:86 P25:146 1.083050000e-03pF
CPEX286 P15:86 P25:149 9.450000000e-07pF
CPEX287 P15:86 P26:152 8.305000000e-05pF
CPEX288 P15:86 P26:155 9.450000000e-07pF
CPEX289 P15:86 P4:20 8.305000000e-05pF
CPEX290 P15:86 P5:26 1.083050000e-03pF
CPEX291 P15:86 P6:32 2.083050000e-03pF
CPEX292 P15:86 P7:38 3.083050000e-03pF
CPEX293 P15:86 P8:44 4.083050000e-03pF
CPEX294 P15:86 P9:50 5.083050000e-03pF
CPEX295 P15:89 P4:20 9.450000000e-07pF
CPEX296 P15:89 P5:26 9.450000000e-07pF
CPEX297 P15:89 P6:32 9.450000000e-07pF
CPEX298 P15:89 P7:38 9.450000000e-07pF
CPEX299 P15:89 P8:44 9.450000000e-07pF
CPEX300 P15:89 P9:50 9.450000000e-07pF
CPEX301 P16:90 P17:100 1.616000000e-02pF
CPEX302 P16:90 P7:36 4.040000000e-03pF
CPEX303 P16:92 P17:101 9.450000000e-07pF
CPEX304 P16:92 P17:98 1.008305000e-02pF
CPEX305 P16:92 P18:104 9.083050000e-03pF
CPEX306 P16:92 P18:107 9.450000000e-07pF
CPEX307 P16:92 P19:110 8.083050000e-03pF
CPEX308 P16:92 P19:113 9.450000000e-07pF
CPEX309 P16:92 P20:116 7.083050000e-03pF
CPEX310 P16:92 P20:119 9.450000000e-07pF
CPEX311 P16:92 P21:122 6.083050000e-03pF
CPEX312 P16:92 P21:125 9.450000000e-07pF
CPEX313 P16:92 P22:128 5.083050000e-03pF
CPEX314 P16:92 P22:131 9.450000000e-07pF
CPEX315 P16:92 P23:134 4.083050000e-03pF
CPEX316 P16:92 P23:137 9.450000000e-07pF
CPEX317 P16:92 P24:140 3.083050000e-03pF
CPEX318 P16:92 P24:143 9.450000000e-07pF
CPEX319 P16:92 P25:146 2.083050000e-03pF
CPEX320 P16:92 P25:149 9.450000000e-07pF
CPEX321 P16:92 P26:152 1.083050000e-03pF
CPEX322 P16:92 P26:155 9.450000000e-07pF
CPEX323 P16:92 P27:158 8.305000000e-05pF
CPEX324 P16:92 P27:161 9.450000000e-07pF
CPEX325 P16:92 P5:26 8.305000000e-05pF
CPEX326 P16:92 P6:32 1.083050000e-03pF
CPEX327 P16:92 P7:38 2.083050000e-03pF
CPEX328 P16:92 P8:44 3.083050000e-03pF
CPEX329 P16:92 P9:50 4.083050000e-03pF
CPEX330 P16:95 P5:26 9.450000000e-07pF
CPEX331 P16:95 P6:32 9.450000000e-07pF
CPEX332 P16:95 P7:38 9.450000000e-07pF
CPEX333 P16:95 P8:44 9.450000000e-07pF
CPEX334 P16:95 P9:50 9.450000000e-07pF
CPEX335 P17:100 P1:0 1.212000000e-01pF
CPEX336 P17:100 P9:48 8.080000000e-03pF
CPEX337 P17:101 P6:32 9.450000000e-07pF
CPEX338 P17:101 P7:38 9.450000000e-07pF
CPEX339 P17:101 P8:44 9.450000000e-07pF
CPEX340 P17:101 P9:50 9.450000000e-07pF
CPEX341 P17:98 P18:104 1.008305000e-02pF
CPEX342 P17:98 P18:107 9.450000000e-07pF
CPEX343 P17:98 P19:110 9.083050000e-03pF
CPEX344 P17:98 P19:113 9.450000000e-07pF
CPEX345 P17:98 P20:116 8.083050000e-03pF
CPEX346 P17:98 P20:119 9.450000000e-07pF
CPEX347 P17:98 P21:122 7.083050000e-03pF
CPEX348 P17:98 P21:125 9.450000000e-07pF
CPEX349 P17:98 P22:128 6.083050000e-03pF
CPEX350 P17:98 P22:131 9.450000000e-07pF
CPEX351 P17:98 P23:134 5.083050000e-03pF
CPEX352 P17:98 P23:137 9.450000000e-07pF
CPEX353 P17:98 P24:140 4.083050000e-03pF
CPEX354 P17:98 P24:143 9.450000000e-07pF
CPEX355 P17:98 P25:146 3.083050000e-03pF
CPEX356 P17:98 P25:149 9.450000000e-07pF
CPEX357 P17:98 P26:152 2.083050000e-03pF
CPEX358 P17:98 P26:155 9.450000000e-07pF
CPEX359 P17:98 P27:158 1.083050000e-03pF
CPEX360 P17:98 P27:161 9.450000000e-07pF
CPEX361 P17:98 P28:164 8.305000000e-05pF
CPEX362 P17:98 P28:167 9.450000000e-07pF
CPEX363 P17:98 P6:32 8.305000000e-05pF
CPEX364 P17:98 P7:38 1.083050000e-03pF
CPEX365 P17:98 P8:44 2.083050000e-03pF
CPEX366 P17:98 P9:50 3.083050000e-03pF
CPEX367 P18:102 P19:108 9.470000000e-03pF
CPEX368 P18:102 P1:0 4.040000000e-03pF
CPEX369 P18:102 P28:162 5.430000000e-03pF
CPEX370 P18:102 P8:42 9.470000000e-03pF
CPEX371 P18:104 P19:110 1.008305000e-02pF
CPEX372 P18:104 P19:113 9.450000000e-07pF
CPEX373 P18:104 P20:116 9.083050000e-03pF
CPEX374 P18:104 P20:119 9.450000000e-07pF
CPEX375 P18:104 P21:122 8.083050000e-03pF
CPEX376 P18:104 P21:125 9.450000000e-07pF
CPEX377 P18:104 P22:128 7.083050000e-03pF
CPEX378 P18:104 P22:131 9.450000000e-07pF
CPEX379 P18:104 P23:134 6.083050000e-03pF
CPEX380 P18:104 P23:137 9.450000000e-07pF
CPEX381 P18:104 P24:140 5.083050000e-03pF
CPEX382 P18:104 P24:143 9.450000000e-07pF
CPEX383 P18:104 P25:146 4.083050000e-03pF
CPEX384 P18:104 P25:149 9.450000000e-07pF
CPEX385 P18:104 P26:152 3.083050000e-03pF
CPEX386 P18:104 P26:155 9.450000000e-07pF
CPEX387 P18:104 P27:158 2.083050000e-03pF
CPEX388 P18:104 P27:161 9.450000000e-07pF
CPEX389 P18:104 P28:164 1.083050000e-03pF
CPEX390 P18:104 P28:167 9.450000000e-07pF
CPEX391 P18:104 P29:170 8.305000000e-05pF
CPEX392 P18:104 P29:173 9.450000000e-07pF
CPEX393 P18:104 P7:38 8.305000000e-05pF
CPEX394 P18:104 P8:44 1.083050000e-03pF
CPEX395 P18:104 P9:50 2.083050000e-03pF
CPEX396 P18:107 P7:38 9.450000000e-07pF
CPEX397 P18:107 P8:44 9.450000000e-07pF
CPEX398 P18:107 P9:50 9.450000000e-07pF
CPEX399 P19:110 P20:116 1.008305000e-02pF
CPEX400 P19:110 P20:119 9.450000000e-07pF
CPEX401 P19:110 P21:122 9.083050000e-03pF
CPEX402 P19:110 P21:125 9.450000000e-07pF
CPEX403 P19:110 P22:128 8.083050000e-03pF
CPEX404 P19:110 P22:131 9.450000000e-07pF
CPEX405 P19:110 P23:134 7.083050000e-03pF
CPEX406 P19:110 P23:137 9.450000000e-07pF
CPEX407 P19:110 P24:140 6.083050000e-03pF
CPEX408 P19:110 P24:143 9.450000000e-07pF
CPEX409 P19:110 P25:146 5.083050000e-03pF
CPEX410 P19:110 P25:149 9.450000000e-07pF
CPEX411 P19:110 P26:152 4.083050000e-03pF
CPEX412 P19:110 P26:155 9.450000000e-07pF
CPEX413 P19:110 P27:158 3.083050000e-03pF
CPEX414 P19:110 P27:161 9.450000000e-07pF
CPEX415 P19:110 P28:164 2.083050000e-03pF
CPEX416 P19:110 P28:167 9.450000000e-07pF
CPEX417 P19:110 P29:170 1.083050000e-03pF
CPEX418 P19:110 P29:173 9.450000000e-07pF
CPEX419 P19:110 P30:176 8.305000000e-05pF
CPEX420 P19:110 P30:179 9.450000000e-07pF
CPEX421 P19:110 P8:44 8.305000000e-05pF
CPEX422 P19:110 P9:50 1.083050000e-03pF
CPEX423 P19:113 P8:44 9.450000000e-07pF
CPEX424 P19:113 P9:50 9.450000000e-07pF
CPEX425 P1:0 P8:42 4.040000000e-03pF
CPEX426 P1:2 P2:11 9.450000000e-07pF
CPEX427 P1:2 P2:8 1.008305000e-02pF
CPEX428 P1:2 P3:14 9.083050000e-03pF
CPEX429 P1:2 P3:17 9.450000000e-07pF
CPEX430 P1:2 P4:20 8.083050000e-03pF
CPEX431 P1:2 P4:23 9.450000000e-07pF
CPEX432 P1:2 P5:26 7.083050000e-03pF
CPEX433 P1:2 P5:29 9.450000000e-07pF
CPEX434 P1:2 P6:32 6.083050000e-03pF
CPEX435 P1:2 P6:35 9.450000000e-07pF
CPEX436 P1:2 P7:38 5.083050000e-03pF
CPEX437 P1:2 P7:41 9.450000000e-07pF
CPEX438 P1:2 P8:44 4.083050000e-03pF
CPEX439 P1:2 P8:47 9.450000000e-07pF
CPEX440 P1:2 P9:50 3.083050000e-03pF
CPEX441 P1:2 P9:53 9.450000000e-07pF
CPEX442 P20:114 P22:126 2.172000000e-02pF
CPEX443 P20:114 P8:42 5.430000000e-03pF
CPEX444 P20:116 P21:122 1.008305000e-02pF
CPEX445 P20:116 P21:125 9.450000000e-07pF
CPEX446 P20:116 P22:128 9.083050000e-03pF
CPEX447 P20:116 P22:131 9.450000000e-07pF
CPEX448 P20:116 P23:134 8.083050000e-03pF
CPEX449 P20:116 P23:137 9.450000000e-07pF
CPEX450 P20:116 P24:140 7.083050000e-03pF
CPEX451 P20:116 P24:143 9.450000000e-07pF
CPEX452 P20:116 P25:146 6.083050000e-03pF
CPEX453 P20:116 P25:149 9.450000000e-07pF
CPEX454 P20:116 P26:152 5.083050000e-03pF
CPEX455 P20:116 P26:155 9.450000000e-07pF
CPEX456 P20:116 P27:158 4.083050000e-03pF
CPEX457 P20:116 P27:161 9.450000000e-07pF
CPEX458 P20:116 P28:164 3.083050000e-03pF
CPEX459 P20:116 P28:167 9.450000000e-07pF
CPEX460 P20:116 P29:170 2.083050000e-03pF
CPEX461 P20:116 P29:173 9.450000000e-07pF
CPEX462 P20:116 P30:176 1.083050000e-03pF
CPEX463 P20:116 P30:179 9.450000000e-07pF
CPEX464 P20:116 P9:50 8.305000000e-05pF
CPEX465 P20:119 P9:50 9.450000000e-07pF
CPEX466 P21:120 P22:126 2.172000000e-02pF
CPEX467 P21:120 P5:24 5.430000000e-03pF
CPEX468 P21:122 P22:128 1.008305000e-02pF
CPEX469 P21:122 P22:131 9.450000000e-07pF
CPEX470 P21:122 P23:134 9.083050000e-03pF
CPEX471 P21:122 P23:137 9.450000000e-07pF
CPEX472 P21:122 P24:140 8.083050000e-03pF
CPEX473 P21:122 P24:143 9.450000000e-07pF
CPEX474 P21:122 P25:146 7.083050000e-03pF
CPEX475 P21:122 P25:149 9.450000000e-07pF
CPEX476 P21:122 P26:152 6.083050000e-03pF
CPEX477 P21:122 P26:155 9.450000000e-07pF
CPEX478 P21:122 P27:158 5.083050000e-03pF
CPEX479 P21:122 P27:161 9.450000000e-07pF
CPEX480 P21:122 P28:164 4.083050000e-03pF
CPEX481 P21:122 P28:167 9.450000000e-07pF
CPEX482 P21:122 P29:170 3.083050000e-03pF
CPEX483 P21:122 P29:173 9.450000000e-07pF
CPEX484 P21:122 P30:176 2.083050000e-03pF
CPEX485 P21:122 P30:179 9.450000000e-07pF
CPEX486 P22:126 P23:132 2.172000000e-02pF
CPEX487 P22:126 P24:138 2.172000000e-02pF
CPEX488 P22:126 P25:144 2.172000000e-02pF
CPEX489 P22:126 P26:150 2.172000000e-02pF
CPEX490 P22:126 P27:156 2.172000000e-02pF
CPEX491 P22:126 P28:162 1.737600000e-01pF
CPEX492 P22:126 P9:48 8.080000000e-03pF
CPEX493 P22:128 P23:134 1.008305000e-02pF
CPEX494 P22:128 P23:137 9.450000000e-07pF
CPEX495 P22:128 P24:140 9.083050000e-03pF
CPEX496 P22:128 P24:143 9.450000000e-07pF
CPEX497 P22:128 P25:146 8.083050000e-03pF
CPEX498 P22:128 P25:149 9.450000000e-07pF
CPEX499 P22:128 P26:152 7.083050000e-03pF
CPEX500 P22:128 P26:155 9.450000000e-07pF
CPEX501 P22:128 P27:158 6.083050000e-03pF
CPEX502 P22:128 P27:161 9.450000000e-07pF
CPEX503 P22:128 P28:164 5.083050000e-03pF
CPEX504 P22:128 P28:167 9.450000000e-07pF
CPEX505 P22:128 P29:170 4.083050000e-03pF
CPEX506 P22:128 P29:173 9.450000000e-07pF
CPEX507 P22:128 P30:176 3.083050000e-03pF
CPEX508 P22:128 P30:179 9.450000000e-07pF
CPEX509 P23:132 P2:10 5.430000000e-03pF
CPEX510 P23:134 P24:140 1.008305000e-02pF
CPEX511 P23:134 P24:143 9.450000000e-07pF
CPEX512 P23:134 P25:146 9.083050000e-03pF
CPEX513 P23:134 P25:149 9.450000000e-07pF
CPEX514 P23:134 P26:152 8.083050000e-03pF
CPEX515 P23:134 P26:155 9.450000000e-07pF
CPEX516 P23:134 P27:158 7.083050000e-03pF
CPEX517 P23:134 P27:161 9.450000000e-07pF
CPEX518 P23:134 P28:164 6.083050000e-03pF
CPEX519 P23:134 P28:167 9.450000000e-07pF
CPEX520 P23:134 P29:170 5.083050000e-03pF
CPEX521 P23:134 P29:173 9.450000000e-07pF
CPEX522 P23:134 P30:176 4.083050000e-03pF
CPEX523 P23:134 P30:179 9.450000000e-07pF
CPEX524 P24:138 P3:12 5.430000000e-03pF
CPEX525 P24:140 P25:146 1.008305000e-02pF
CPEX526 P24:140 P25:149 9.450000000e-07pF
CPEX527 P24:140 P26:152 9.083050000e-03pF
CPEX528 P24:140 P26:155 9.450000000e-07pF
CPEX529 P24:140 P27:158 8.083050000e-03pF
CPEX530 P24:140 P27:161 9.450000000e-07pF
CPEX531 P24:140 P28:164 7.083050000e-03pF
CPEX532 P24:140 P28:167 9.450000000e-07pF
CPEX533 P24:140 P29:170 6.083050000e-03pF
CPEX534 P24:140 P29:173 9.450000000e-07pF
CPEX535 P24:140 P30:176 5.083050000e-03pF
CPEX536 P24:140 P30:179 9.450000000e-07pF
CPEX537 P25:144 P4:18 5.430000000e-03pF
CPEX538 P25:146 P26:152 1.008305000e-02pF
CPEX539 P25:146 P26:155 9.450000000e-07pF
CPEX540 P25:146 P27:158 9.083050000e-03pF
CPEX541 P25:146 P27:161 9.450000000e-07pF
CPEX542 P25:146 P28:164 8.083050000e-03pF
CPEX543 P25:146 P28:167 9.450000000e-07pF
CPEX544 P25:146 P29:170 7.083050000e-03pF
CPEX545 P25:146 P29:173 9.450000000e-07pF
CPEX546 P25:146 P30:176 6.083050000e-03pF
CPEX547 P25:146 P30:179 9.450000000e-07pF
CPEX548 P26:150 P6:30 5.430000000e-03pF
CPEX549 P26:152 P27:158 1.008305000e-02pF
CPEX550 P26:152 P27:161 9.450000000e-07pF
CPEX551 P26:152 P28:164 9.083050000e-03pF
CPEX552 P26:152 P28:167 9.450000000e-07pF
CPEX553 P26:152 P29:170 8.083050000e-03pF
CPEX554 P26:152 P29:173 9.450000000e-07pF
CPEX555 P26:152 P30:176 7.083050000e-03pF
CPEX556 P26:152 P30:179 9.450000000e-07pF
CPEX557 P27:156 P7:36 5.430000000e-03pF
CPEX558 P27:158 P28:164 1.008305000e-02pF
CPEX559 P27:158 P28:167 9.450000000e-07pF
CPEX560 P27:158 P29:170 9.083050000e-03pF
CPEX561 P27:158 P29:173 9.450000000e-07pF
CPEX562 P27:158 P30:176 8.083050000e-03pF
CPEX563 P27:158 P30:179 9.450000000e-07pF
CPEX564 P28:162 P8:42 5.430000000e-03pF
CPEX565 P28:164 P29:170 1.008305000e-02pF
CPEX566 P28:164 P29:173 9.450000000e-07pF
CPEX567 P28:164 P30:176 9.083050000e-03pF
CPEX568 P28:164 P30:179 9.450000000e-07pF
CPEX569 P29:170 P30:176 1.008305000e-02pF
CPEX570 P29:170 P30:179 9.450000000e-07pF
CPEX571 P2:10 P3:12 9.470000000e-03pF
CPEX572 P2:10 P8:42 9.470000000e-03pF
CPEX573 P2:8 P3:14 1.008305000e-02pF
CPEX574 P2:8 P3:17 9.450000000e-07pF
CPEX575 P2:8 P4:20 9.083050000e-03pF
CPEX576 P2:8 P4:23 9.450000000e-07pF
CPEX577 P2:8 P5:26 8.083050000e-03pF
CPEX578 P2:8 P5:29 9.450000000e-07pF
CPEX579 P2:8 P6:32 7.083050000e-03pF
CPEX580 P2:8 P6:35 9.450000000e-07pF
CPEX581 P2:8 P7:38 6.083050000e-03pF
CPEX582 P2:8 P7:41 9.450000000e-07pF
CPEX583 P2:8 P8:44 5.083050000e-03pF
CPEX584 P2:8 P8:47 9.450000000e-07pF
CPEX585 P2:8 P9:50 4.083050000e-03pF
CPEX586 P2:8 P9:53 9.450000000e-07pF
CPEX587 P3:12 P4:18 9.470000000e-03pF
CPEX588 P3:14 P4:20 1.008305000e-02pF
CPEX589 P3:14 P4:23 9.450000000e-07pF
CPEX590 P3:14 P5:26 9.083050000e-03pF
CPEX591 P3:14 P5:29 9.450000000e-07pF
CPEX592 P3:14 P6:32 8.083050000e-03pF
CPEX593 P3:14 P6:35 9.450000000e-07pF
CPEX594 P3:14 P7:38 7.083050000e-03pF
CPEX595 P3:14 P7:41 9.450000000e-07pF
CPEX596 P3:14 P8:44 6.083050000e-03pF
CPEX597 P3:14 P8:47 9.450000000e-07pF
CPEX598 P3:14 P9:50 5.083050000e-03pF
CPEX599 P3:14 P9:53 9.450000000e-07pF
CPEX600 P4:18 P5:24 9.470000000e-03pF
CPEX601 P4:20 P5:26 1.008305000e-02pF
CPEX602 P4:20 P5:29 9.450000000e-07pF
CPEX603 P4:20 P6:32 9.083050000e-03pF
CPEX604 P4:20 P6:35 9.450000000e-07pF
CPEX605 P4:20 P7:38 8.083050000e-03pF
CPEX606 P4:20 P7:41 9.450000000e-07pF
CPEX607 P4:20 P8:44 7.083050000e-03pF
CPEX608 P4:20 P8:47 9.450000000e-07pF
CPEX609 P4:20 P9:50 6.083050000e-03pF
CPEX610 P4:20 P9:53 9.450000000e-07pF
CPEX611 P5:24 P6:30 9.470000000e-03pF
CPEX612 P5:26 P6:32 1.008305000e-02pF
CPEX613 P5:26 P6:35 9.450000000e-07pF
CPEX614 P5:26 P7:38 9.083050000e-03pF
CPEX615 P5:26 P7:41 9.450000000e-07pF
CPEX616 P5:26 P8:44 8.083050000e-03pF
CPEX617 P5:26 P8:47 9.450000000e-07pF
CPEX618 P5:26 P9:50 7.083050000e-03pF
CPEX619 P5:26 P9:53 9.450000000e-07pF
CPEX620 P6:30 P7:36 9.470000000e-03pF
CPEX621 P6:32 P7:38 1.008305000e-02pF
CPEX622 P6:32 P7:41 9.450000000e-07pF
CPEX623 P6:32 P8:44 9.083050000e-03pF
CPEX624 P6:32 P8:47 9.450000000e-07pF
CPEX625 P6:32 P9:50 8.083050000e-03pF
CPEX626 P6:32 P9:53 9.450000000e-07pF
CPEX627 P7:36 P8:42 9.470000000e-03pF
CPEX628 P7:38 P8:44 1.008305000e-02pF
CPEX629 P7:38 P8:47 9.450000000e-07pF
CPEX630 P7:38 P9:50 9.083050000e-03pF
CPEX631 P7:38 P9:53 9.450000000e-07pF
CPEX632 P8:44 P9:50 1.008305000e-02pF
CPEX633 P8:44 P9:53 9.450000000e-07pF
RPEX634 P1:0 P1:2 3.078625000e+01
RPEX635 P1:2 P1:1 3.078625000e+01
RPEX636 P1:3 P1:5 1.203650000e+00
RPEX637 P1:5 P1:4 1.203650000e+00
RPEX638 P2:6 P2:8 3.078625000e+01
RPEX639 P2:8 P2:7 3.078625000e+01
RPEX640 P2:9 P2:11 1.203650000e+00
RPEX641 P2:11 P2:10 1.203650000e+00
RPEX642 P3:12 P3:14 3.078625000e+01
RPEX643 P3:14 P3:13 3.078625000e+01
RPEX644 P3:15 P3:17 1.203650000e+00
RPEX645 P3:17 P3:16 1.203650000e+00
RPEX646 P4:18 P4:20 3.078625000e+01
RPEX647 P4:20 P4:19 3.078625000e+01
RPEX648 P4:21 P4:23 1.203650000e+00
RPEX649 P4:23 P4:22 1.203650000e+00
RPEX650 P5:24 P5:26 3.078625000e+01
RPEX651 P5:26 P5:25 3.078625000e+01
RPEX652 P5:27 P5:29 1.203650000e+00
RPEX653 P5:29 P5:28 1.203650000e+00
RPEX654 P6:30 P6:32 3.078625000e+01
RPEX655 P6:32 P6:31 3.078625000e+01
RPEX656 P6:33 P6:35 1.203650000e+00
RPEX657 P6:35 P6:34 1.203650000e+00
RPEX658 P7:36 P7:38 3.078625000e+01
RPEX659 P7:38 P7:37 3.078625000e+01
RPEX660 P7:39 P7:41 1.203650000e+00
RPEX661 P7:41 P7:40 1.203650000e+00
RPEX662 P8:42 P8:44 3.078625000e+01
RPEX663 P8:44 P8:43 3.078625000e+01
RPEX664 P8:45 P8:47 1.203650000e+00
RPEX665 P8:47 P8:46 1.203650000e+00
RPEX666 P9:48 P9:50 3.078625000e+01
RPEX667 P9:50 P9:49 3.078625000e+01
RPEX668 P9:51 P9:53 1.203650000e+00
RPEX669 P9:53 P9:52 1.203650000e+00
RPEX670 P10:54 P10:56 3.078625000e+01
RPEX671 P10:56 P10:55 3.078625000e+01
RPEX672 P10:57 P10:59 1.203650000e+00
RPEX673 P10:59 P10:58 1.203650000e+00
RPEX674 P11:60 P11:62 3.078625000e+01
RPEX675 P11:62 P11:61 3.078625000e+01
RPEX676 P11:63 P11:65 1.203650000e+00
RPEX677 P11:65 P11:64 1.203650000e+00
RPEX678 P12:66 P12:68 3.078625000e+01
RPEX679 P12:68 P12:67 3.078625000e+01
RPEX680 P12:69 P12:71 1.203650000e+00
RPEX681 P12:71 P12:70 1.203650000e+00
RPEX682 P13:72 P13:74 3.078625000e+01
RPEX683 P13:74 P13:73 3.078625000e+01
RPEX684 P13:75 P13:77 1.203650000e+00
RPEX685 P13:77 P13:76 1.203650000e+00
RPEX686 P14:78 P14:80 3.078625000e+01
RPEX687 P14:80 P14:79 3.078625000e+01
RPEX688 P14:81 P14:83 1.203650000e+00
RPEX689 P14:83 P14:82 1.203650000e+00
RPEX690 P15:84 P15:86 3.078625000e+01
RPEX691 P15:86 P15:85 3.078625000e+01
RPEX692 P15:87 P15:89 1.203650000e+00
RPEX693 P15:89 P15:88 1.203650000e+00
RPEX694 P16:90 P16:92 3.078625000e+01
RPEX695 P16:92 P16:91 3.078625000e+01
RPEX696 P16:93 P16:95 1.203650000e+00
RPEX697 P16:95 P16:94 1.203650000e+00
RPEX698 P17:96 P17:98 3.078625000e+01
RPEX699 P17:98 P17:97 3.078625000e+01
RPEX700 P17:99 P17:101 1.203650000e+00
RPEX701 P17:101 P17:100 1.203650000e+00
RPEX702 P18:102 P18:104 3.078625000e+01
RPEX703 P18:104 P18:103 3.078625000e+01
RPEX704 P18:105 P18:107 1.203650000e+00
RPEX705 P18:107 P18:106 1.203650000e+00
RPEX706 P19:108 P19:110 3.078625000e+01
RPEX707 P19:110 P19:109 3.078625000e+01
RPEX708 P19:111 P19:113 1.203650000e+00
RPEX709 P19:113 P19:112 1.203650000e+00
RPEX710 P20:114 P20:116 3.078625000e+01
RPEX711 P20:116 P20:115 3.078625000e+01
RPEX712 P20:117 P20:119 1.203650000e+00
RPEX713 P20:119 P20:118 1.203650000e+00
RPEX714 P21:120 P21:122 3.078625000e+01
RPEX715 P21:122 P21:121 3.078625000e+01
RPEX716 P21:123 P21:125 1.203650000e+00
RPEX717 P21:125 P21:124 1.203650000e+00
RPEX718 P22:126 P22:128 3.078625000e+01
RPEX719 P22:128 P22:127 3.078625000e+01
RPEX720 P22:129 P22:131 1.203650000e+00
RPEX721 P22:131 P22:130 1.203650000e+00
RPEX722 P23:132 P23:134 3.078625000e+01
RPEX723 P23:134 P23:133 3.078625000e+01
RPEX724 P23:135 P23:137 1.203650000e+00
RPEX725 P23:137 P23:136 1.203650000e+00
RPEX726 P24:138 P24:140 3.078625000e+01
RPEX727 P24:140 P24:139 3.078625000e+01
RPEX728 P24:141 P24:143 1.203650000e+00
RPEX729 P24:143 P24:142 1.203650000e+00
RPEX730 P25:144 P25:146 3.078625000e+01
RPEX731 P25:146 P25:145 3.078625000e+01
RPEX732 P25:147 P25:149 1.203650000e+00
RPEX733 P25:149 P25:148 1.203650000e+00
RPEX734 P26:150 P26:152 3.078625000e+01
RPEX735 P26:152 P26:151 3.078625000e+01
RPEX736 P26:153 P26:155 1.203650000e+00
RPEX737 P26:155 P26:154 1.203650000e+00
RPEX738 P27:156 P27:158 3.078625000e+01
RPEX739 P27:158 P27:157 3.078625000e+01
RPEX740 P27:159 P27:161 1.203650000e+00
RPEX741 P27:161 P27:160 1.203650000e+00
RPEX742 P28:162 P28:164 3.078625000e+01
RPEX743 P28:164 P28:163 3.078625000e+01
RPEX744 P28:165 P28:167 1.203650000e+00
RPEX745 P28:167 P28:166 1.203650000e+00
RPEX746 P29:168 P29:170 3.078625000e+01
RPEX747 P29:170 P29:169 3.078625000e+01
RPEX748 P29:171 P29:173 1.203650000e+00
RPEX749 P29:173 P29:172 1.203650000e+00
RPEX750 P30:174 P30:176 3.078625000e+01
RPEX751 P30:176 P30:175 3.078625000e+01
RPEX752 P30:177 P30:179 1.203650000e+00
RPEX753 P30:179 P30:178 1.203650000e+00
RPEX754 P1:0 P1:3 1.000000000e+00
RPEX755 P2:6 P2:9 1.000000000e+00
RPEX756 P3:12 P3:15 1.000000000e+00
RPEX757 P4:18 P4:21 1.000000000e+00
RPEX758 P5:24 P5:27 1.000000000e+00
RPEX759 P6:30 P6:33 1.000000000e+00
RPEX760 P7:36 P7:39 1.000000000e+00
RPEX761 P8:42 P8:45 1.000000000e+00
RPEX762 P9:48 P9:51 1.000000000e+00
RPEX763 P10:54 P10:57 1.000000000e+00
RPEX764 P11:60 P11:63 1.000000000e+00
RPEX765 P12:66 P12:69 1.000000000e+00
RPEX766 P13:72 P13:75 1.000000000e+00
RPEX767 P14:78 P14:81 1.000000000e+00
RPEX768 P15:84 P15:87 1.000000000e+00
RPEX769 P16:90 P16:93 1.000000000e+00
RPEX770 P17:96 P17:99 1.000000000e+00
RPEX771 P18:102 P18:105 1.000000000e+00
RPEX772 P19:108 P19:111 1.000000000e+00
RPEX773 P20:114 P20:117 1.000000000e+00
RPEX774 P21:120 P21:123 1.000000000e+00
RPEX775 P22:126 P22:129 1.000000000e+00
RPEX776 P23:132 P23:135 1.000000000e+00
RPEX777 P24:138 P24:141 1.000000000e+00
RPEX778 P25:144 P25:147 1.000000000e+00
RPEX779 P26:150 P26:153 1.000000000e+00
RPEX780 P27:156 P27:159 1.000000000e+00
RPEX781 P28:162 P28:165 1.000000000e+00
RPEX782 P29:168 P29:171 1.000000000e+00
RPEX783 P30:174 P30:177 1.000000000e+00
RPEX784 P1 P1:3 0.000000000e+00
RPEX785 P2 P2:9 0.000000000e+00
RPEX786 P3 P3:15 0.000000000e+00
RPEX787 P4 P4:18 0.000000000e+00
RPEX788 P5 P5:27 0.000000000e+00
RPEX789 P6 P6:33 0.000000000e+00
RPEX790 P7 P7:39 0.000000000e+00
RPEX791 P8 P8:42 0.000000000e+00
RPEX792 P9 P9:48 0.000000000e+00
RPEX793 P10 P10:54 0.000000000e+00
RPEX794 P11 P11:63 0.000000000e+00
RPEX795 P12 P12:66 0.000000000e+00
RPEX796 P13 P13:72 0.000000000e+00
RPEX797 P14 P14:78 0.000000000e+00
RPEX798 P15 P15:84 0.000000000e+00
RPEX799 P16 P16:93 0.000000000e+00
RPEX800 P17 P17:99 0.000000000e+00
RPEX801 P18 P18:102 0.000000000e+00
RPEX802 P19 P19:108 0.000000000e+00
RPEX803 P20 P20:117 0.000000000e+00
RPEX804 P21 P21:123 0.000000000e+00
RPEX805 P22 P22:126 0.000000000e+00
RPEX806 P23 P23:135 0.000000000e+00
RPEX807 P24 P24:141 0.000000000e+00
RPEX808 P25 P25:147 0.000000000e+00
RPEX809 P26 P26:150 0.000000000e+00
RPEX810 P27 P27:159 0.000000000e+00
RPEX811 P28 P28:165 0.000000000e+00
RPEX812 P29 P29:171 0.000000000e+00
RPEX813 P30 P30:174 0.000000000e+00
.ENDS tr1um_parasitics
