**
.subckt FA1D1 A CO B CI S VDD GND
*.ipin A
*.opin CO
*.ipin B
*.ipin CI
*.opin S
XP03 n01p A VDD VDD PMOS w=10.2u l=1u nrd=0 nrs=0 m=1
XP04 COB B n01p VDD PMOS w=10.2u l=1u nrd=0 nrs=0 m=1
XN04 COB B n01n GND NMOS w=3.4u l=1u nrd=0 nrs=0 m=1
XN03 n01n A GND GND NMOS w=3.4u l=1u nrd=0 nrs=0 m=1
XP00 n00p A VDD VDD PMOS w=10.2u l=1u nrd=0 nrs=0 m=1
XP01 n00p B VDD VDD PMOS w=10.2u l=1u nrd=0 nrs=0 m=1
XP02 COB CI n00p VDD PMOS w=10.2u l=1u nrd=0 nrs=0 m=1
XN02 COB CI n00n GND NMOS w=3.4u l=1u nrd=0 nrs=0 m=1
XN01 n00n B GND GND NMOS w=3.4u l=1u nrd=0 nrs=0 m=1
XN00 n00n A GND GND NMOS w=3.4u l=1u nrd=0 nrs=0 m=1
XCOIVP CO COB VDD VDD PMOS w=10.2u l=1u nrd=0 nrs=0 m=1
XCOIVN CO COB GND GND NMOS w=3.4u l=1u nrd=0 nrs=0 m=1
XP05 n02p A VDD VDD PMOS w=10.2u l=1u nrd=0 nrs=0 m=1
XP06 n02p B VDD VDD PMOS w=10.2u l=1u nrd=0 nrs=0 m=1
XP08 SB COB n02p VDD PMOS w=10.2u l=1u nrd=0 nrs=0 m=1
XN08 SB COB n02n GND NMOS w=3.4u l=1u nrd=0 nrs=0 m=1
XN06 n02n B GND GND NMOS w=3.4u l=1u nrd=0 nrs=0 m=1
XN05 n02n A GND GND NMOS w=3.4u l=1u nrd=0 nrs=0 m=1
XP07 n02p CI VDD VDD PMOS w=10.2u l=1u nrd=0 nrs=0 m=1
XN07 n02n CI GND GND NMOS w=3.4u l=1u nrd=0 nrs=0 m=1
XP09 n03p A VDD VDD PMOS w=10.2u l=1u nrd=0 nrs=0 m=1
XP10 n04p B n03p VDD PMOS w=10.2u l=1u nrd=0 nrs=0 m=1
XN10 n04n B n03n GND NMOS w=3.4u l=1u nrd=0 nrs=0 m=1
XN09 n03n A GND GND NMOS w=3.4u l=1u nrd=0 nrs=0 m=1
XN11 SB CI n04n GND NMOS w=3.4u l=1u nrd=0 nrs=0 m=1
XP11 SB CI n04p VDD PMOS w=10.2u l=1u nrd=0 nrs=0 m=1
XSIVN S SB GND GND NMOS w=3.4u l=1u nrd=0 nrs=0 m=1
XSIVP1 S SB VDD VDD PMOS w=10.2u l=1u nrd=0 nrs=0 m=1
.ends
**.GLOBAL VDD
**.GLOBAL GND
**.end
