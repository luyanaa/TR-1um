**
*.subckt DFFQU1 CK D Q CKB CKP VDD GND
.subckt DFFQU1 CK D Q VDD GND
*.ipin CK
*.ipin D
*.opin Q
MXCKIV1P CKB CK VDD VDD PMOS w=10.2u l=1u nrd=0 nrs=0 m=1
MXCKIV2P CKP CKB VDD VDD PMOS w=10.2u l=1u nrd=0 nrs=0 m=1
MXCKIV1P1 net1 D VDD VDD PMOS w=10.2u l=1u nrd=0 nrs=0 m=1
MXCKIV1P2 ml_ax CKP net1 VDD PMOS w=10.2u l=1u nrd=0 nrs=0 m=1
MXIV1P ml_b ml_ax VDD VDD PMOS w=10.2u l=1u nrd=0 nrs=0 m=1
MXCKIV2P1 net3 ml_b VDD VDD PMOS w=10.2u l=1u nrd=0 nrs=0 m=1
MXCKIV2P2 ml_ax CKB net3 VDD PMOS w=10.2u l=1u nrd=0 nrs=0 m=1
MXTFGP ml_b CKB sl_ax VDD PMOS w=10.2u l=1u nrd=0 nrs=0 m=1
MXCKIV3P1 net5 sl_b VDD VDD PMOS w=10.2u l=1u nrd=0 nrs=0 m=1
MXCKIV3P2 sl_ax CKP net5 VDD PMOS w=10.2u l=1u nrd=0 nrs=0 m=1
MXOUTIVP Q sl_b VDD VDD PMOS w=10.2u l=1u nrd=0 nrs=0 m=1
MXCKIV1N CKB CK GND GND NMOS w=3.4u l=1u nrd=0 nrs=0 m=1
MXCKIV2N CKP CKB GND GND NMOS w=3.4u l=1u nrd=0 nrs=0 m=1
MXCKIV1N2 ml_ax CKB net2 GND NMOS w=3.4u l=1u nrd=0 nrs=0 m=1
MXCKIV1N1 net2 D GND GND NMOS w=3.4u l=1u nrd=0 nrs=0 m=1
MXIV1N ml_b ml_ax GND GND NMOS w=3.4u l=1u nrd=0 nrs=0 m=1
MXTFGN ml_b CKP sl_ax GND NMOS w=3.4u l=1u nrd=0 nrs=0 m=1
MXOUTIVN Q sl_b GND GND NMOS w=3.4u l=1u nrd=0 nrs=0 m=1
MXCKIV3N2 sl_ax CKB net6 GND NMOS w=3.4u l=1u nrd=0 nrs=0 m=1
MXCKIV3N1 net6 sl_b GND GND NMOS w=3.4u l=1u nrd=0 nrs=0 m=1
MXCKIV2N2 ml_ax CKP net4 GND NMOS w=3.4u l=1u nrd=0 nrs=0 m=1
MXCKIV2N1 net4 ml_b GND GND NMOS w=3.4u l=1u nrd=0 nrs=0 m=1
MXIV2P sl_b sl_ax VDD VDD PMOS w=10.2u l=1u nrd=0 nrs=0 m=1
MXIV2N sl_b sl_ax GND GND NMOS w=3.4u l=1u nrd=0 nrs=0 m=1
.ends
*.GLOBAL VDD
*.GLOBAL GND
*.end
**
.subckt FA1D1 A CO B CI S VDD GND
*.ipin A
*.opin CO
*.ipin B
*.ipin CI
*.opin S
MXP03 n01p A VDD VDD PMOS w=10.2u l=1u nrd=0 nrs=0 m=1
MXP04 COB B n01p VDD PMOS w=10.2u l=1u nrd=0 nrs=0 m=1
MXN04 COB B n01n GND NMOS w=3.4u l=1u nrd=0 nrs=0 m=1
MXN03 n01n A GND GND NMOS w=3.4u l=1u nrd=0 nrs=0 m=1
MXP00 n00p A VDD VDD PMOS w=10.2u l=1u nrd=0 nrs=0 m=1
MXP01 n00p B VDD VDD PMOS w=10.2u l=1u nrd=0 nrs=0 m=1
MXP02 COB CI n00p VDD PMOS w=10.2u l=1u nrd=0 nrs=0 m=1
MXN02 COB CI n00n GND NMOS w=3.4u l=1u nrd=0 nrs=0 m=1
MXN01 n00n B GND GND NMOS w=3.4u l=1u nrd=0 nrs=0 m=1
MXN00 n00n A GND GND NMOS w=3.4u l=1u nrd=0 nrs=0 m=1
MXCOIVP CO COB VDD VDD PMOS w=10.2u l=1u nrd=0 nrs=0 m=1
MXCOIVN CO COB GND GND NMOS w=3.4u l=1u nrd=0 nrs=0 m=1
MXP05 n02p A VDD VDD PMOS w=10.2u l=1u nrd=0 nrs=0 m=1
MXP06 n02p B VDD VDD PMOS w=10.2u l=1u nrd=0 nrs=0 m=1
MXP08 SB COB n02p VDD PMOS w=10.2u l=1u nrd=0 nrs=0 m=1
MXN08 SB COB n02n GND NMOS w=3.4u l=1u nrd=0 nrs=0 m=1
MXN06 n02n B GND GND NMOS w=3.4u l=1u nrd=0 nrs=0 m=1
MXN05 n02n A GND GND NMOS w=3.4u l=1u nrd=0 nrs=0 m=1
MXP07 n02p CI VDD VDD PMOS w=10.2u l=1u nrd=0 nrs=0 m=1
MXN07 n02n CI GND GND NMOS w=3.4u l=1u nrd=0 nrs=0 m=1
MXP09 n03p A VDD VDD PMOS w=10.2u l=1u nrd=0 nrs=0 m=1
MXP10 n04p B n03p VDD PMOS w=10.2u l=1u nrd=0 nrs=0 m=1
MXN10 n04n B n03n GND NMOS w=3.4u l=1u nrd=0 nrs=0 m=1
MXN09 n03n A GND GND NMOS w=3.4u l=1u nrd=0 nrs=0 m=1
MXN11 SB CI n04n GND NMOS w=3.4u l=1u nrd=0 nrs=0 m=1
MXP11 SB CI n04p VDD PMOS w=10.2u l=1u nrd=0 nrs=0 m=1
MXSIVN S SB GND GND NMOS w=3.4u l=1u nrd=0 nrs=0 m=1
MXSIVP1 S SB VDD VDD PMOS w=10.2u l=1u nrd=0 nrs=0 m=1
.ends
**.GLOBAL VDD
**.GLOBAL GND
**.end
**
.subckt HA1S A B CO S VDD GND
*.ipin A
*.ipin B
*.opin CO
*.opin S
MXXNDPA NDOUT A VDD VDD PMOS w=10.2u l=1u nrd=0 nrs=0 m=1
MXXNDNB NDOUT A net1 GND NMOS w=3.4u l=1u nrd=0 nrs=0 m=1
MXXNDPB NDOUT B VDD VDD PMOS w=10.2u l=1u nrd=0 nrs=0 m=1
MXXNDNA net1 B GND GND NMOS w=3.4u l=1u nrd=0 nrs=0 m=1
MXXIV3 CO NDOUT VDD VDD PMOS w=10.2u l=1u nrd=0 nrs=0 m=1
MXXIV4 CO NDOUT GND GND NMOS w=3.4u l=1u nrd=0 nrs=0 m=1
MXXIV1P net2 B net3 VDD PMOS w=10.2u l=1u nrd=0 nrs=0 m=1
MXXIV1N net2 A GND GND NMOS w=3.4u l=1u nrd=0 nrs=0 m=1
MXXIV1 net3 A VDD VDD PMOS w=10.2u l=1u nrd=0 nrs=0 m=1
MXXIV2 net2 B GND GND NMOS w=3.4u l=1u nrd=0 nrs=0 m=1
MXXIV5 S net2 net4 VDD PMOS w=10.2u l=1u nrd=0 nrs=0 m=1
MXXIV6 net4 A VDD VDD PMOS w=10.2u l=1u nrd=0 nrs=0 m=1
MXXIV7 S net2 GND GND NMOS w=3.4u l=1u nrd=0 nrs=0 m=1
MXXIV8 S A net5 GND NMOS w=3.4u l=1u nrd=0 nrs=0 m=1
MXXIV9 net5 B GND GND NMOS w=3.4u l=1u nrd=0 nrs=0 m=1
MXXIV10 net4 B VDD VDD PMOS w=10.2u l=1u nrd=0 nrs=0 m=1
.ends
**.GLOBAL VDD
**.GLOBAL GND
**.end
