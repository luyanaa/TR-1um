* TR-1um N-diffusion antenna diode; the substrate is global VSS.
.model DN D tnom=27
+ is=1.0e-17 rs=47.59 cj=2.76e-17
+ cjsw=1.17e-17 imax=10 imelt=10 xti=0.492 n=1.00129
+ ikf=4.051e-5 bv=14.45 ibv=1.0e-6
.SUBCKT DIODE_N_X1 DIODE VSS
D$1 VSS DIODE DN A=21.60P P=19.2U
.ENDS DIODE_N_X1
