* Generated strict digital-core LVS contract; do not hand-edit.

* Connectivity: powered routed Verilog. Leaf devices: checked-in cell CDL.

.SUBCKT tr1um_uarttx_big clk tx VDD VSS
X_110_ \phase[7] _048_ VDD VSS INV_X1
X_111_ \phase[8] _049_ VDD VSS INV_X1
X_112_ \phase[9] _050_ VDD VSS INV_X1
X_113_ \phase[11] _051_ VDD VSS INV_X1
X_114_ \phase[12] _052_ VDD VSS INV_X1
X_115_ \phase[14] _053_ VDD VSS INV_X1
X_116_ _000_ _054_ VDD VSS INV_X1
X_117_ \phase[1] \phase[0] _055_ VDD VSS NAND2
X_118_ \phase[0] _009_ \phase[1] VDD VSS XOR2
X_119_ _056_ \phase[1] \phase[0] \phase[2] VDD VSS NAND3
X_120_ _055_ _010_ \phase[2] VDD VSS XNOR2
X_121_ \phase[1] _057_ \phase[2] \phase[0] \phase[3] VDD VSS AND4_X1
X_122_ _056_ _011_ \phase[3] VDD VSS XNOR2
X_123_ \phase[4] _057_ _058_ VDD VSS NAND2
X_124_ _057_ _012_ \phase[4] VDD VSS XOR2
X_125_ _059_ \phase[4] \phase[5] _057_ VDD VSS NAND3
X_126_ _058_ _013_ \phase[5] VDD VSS XNOR2
X_127_ \phase[4] \phase[5] _060_ \phase[6] _057_ VDD VSS NAND4
X_128_ _059_ _014_ \phase[6] VDD VSS XNOR2
X_129_ _048_ _060_ _061_ VDD VSS NOR2
X_130_ _060_ _015_ \phase[7] VDD VSS XNOR2
X_131_ _062_ _048_ _060_ _049_ VDD VSS NOR3
X_132_ _061_ _016_ _049_ VDD VSS XNOR2
X_133_ _063_ \phase[7] \phase[8] \phase[9] VDD VSS NAND3
X_134_ _060_ _063_ _064_ VDD VSS NOR2
X_135_ _062_ _017_ _050_ VDD VSS XNOR2
X_136_ \phase[10] _064_ _065_ VDD VSS NAND2
X_137_ _064_ _003_ \phase[10] VDD VSS XOR2
X_138_ _066_ \phase[10] \phase[11] _064_ VDD VSS NAND3
X_139_ _065_ _004_ \phase[11] VDD VSS XNOR2
X_140_ \phase[11] \phase[12] _067_ VDD VSS NAND2
X_141_ _065_ _067_ _068_ VDD VSS NOR2
X_142_ _066_ _005_ \phase[12] VDD VSS XNOR2
X_143_ _052_ \phase[13] _069_ VDD VSS NOR2
X_144_ \phase[13] _068_ _070_ VDD VSS NAND2
X_145_ _068_ _006_ \phase[13] VDD VSS XOR2
X_146_ \phase[12] _071_ \phase[11] VDD VSS XNOR2
X_147_ _070_ _007_ _001_ VDD VSS XOR2
X_148_ _072_ \phase[13] \phase[14] _068_ VDD VSS NAND3
X_149_ _072_ _008_ \phase[15] VDD VSS XNOR2
X_150_ \phase[14] _067_ _073_ VDD VSS NAND2
X_151_ \phase[9] \phase[10] _074_ VDD VSS NOR2
X_152_ \phase[7] \phase[8] _075_ _073_ _074_ VDD VSS NAND4
X_153_ _051_ \phase[12] _076_ VDD VSS NOR2
X_154_ \phase[11] _052_ _077_ VDD VSS NOR2
X_155_ _051_ \phase[12] _078_ VDD VSS NAND2
X_156_ \phase[13] _078_ _079_ VDD VSS AND2_X1
X_157_ \phase[13] _071_ _080_ VDD VSS AND2_X1
X_158_ \phase[13] _077_ _081_ VDD VSS NOR2
X_159_ _080_ _081_ _082_ VDD VSS NOR2
X_160_ \phase[14] _082_ _083_ VDD VSS NOR2
X_161_ _075_ _083_ _084_ VDD VSS NOR2
X_162_ \phase[7] _049_ _085_ VDD VSS NAND2
X_163_ _086_ _050_ _085_ \phase[10] VDD VSS OR3
X_164_ _087_ \phase[14] _079_ _069_ VDD VSS NOR3
X_165_ _088_ \phase[13] _078_ _053_ VDD VSS NOR3
X_166_ _087_ _088_ _089_ VDD VSS NOR2
X_167_ \phase[13] _067_ _090_ VDD VSS NOR2
X_168_ _086_ _089_ _091_ VDD VSS NOR2
X_169_ _092_ _051_ \phase[13] \phase[12] VDD VSS NOR3
X_170_ _093_ _053_ _092_ _080_ VDD VSS NOR3
X_171_ _051_ \phase[12] _094_ \phase[13] VDD VSS AND3_X1
X_172_ _095_ \phase[14] _094_ _090_ VDD VSS NOR3
X_173_ _093_ _095_ _096_ VDD VSS NOR2
X_174_ _085_ _096_ _018_ VDD VSS NOR2
X_175_ \phase[13] _071_ _019_ VDD VSS NOR2
X_176_ _048_ \phase[8] _020_ VDD VSS NAND2
X_177_ \phase[14] _078_ _021_ VDD VSS NOR2
X_178_ _022_ _080_ _019_ _021_ _020_ VDD VSS NOR4
X_179_ _018_ _022_ _023_ VDD VSS NOR2
X_180_ _024_ \phase[9] _023_ \phase[10] VDD VSS NOR3
X_181_ _025_ _084_ _024_ _091_ VDD VSS NOR3
X_182_ \phase[15] _025_ _026_ VDD VSS NOR2
X_183_ _053_ \phase[15] _027_ VDD VSS NAND2
X_184_ _028_ \phase[13] _086_ _077_ VDD VSS OR3
X_185_ _069_ _075_ _029_ VDD VSS NOR2
X_186_ _071_ _029_ _030_ VDD VSS NAND2
X_187_ \phase[13] _054_ _031_ VDD VSS NOR2
X_188_ _032_ _094_ _031_ _020_ VDD VSS NOR3
X_189_ _033_ \phase[11] _085_ _069_ VDD VSS NOR3
X_190_ _032_ _033_ _034_ VDD VSS OR2
X_191_ _074_ _034_ _035_ VDD VSS NAND2
X_192_ _028_ _030_ _036_ _035_ VDD VSS AND3_X1
X_193_ _027_ _036_ _037_ VDD VSS NOR2
X_194_ _038_ _002_ _027_ _076_ VDD VSS NOR3
X_195_ _039_ \phase[14] _019_ _079_ VDD VSS NOR3
X_196_ _053_ _077_ _040_ VDD VSS NOR2
X_197_ _041_ \phase[15] _040_ _039_ VDD VSS NOR3
X_198_ _038_ _041_ _042_ VDD VSS NOR2
X_199_ _048_ _049_ _043_ VDD VSS NAND2
X_200_ _044_ _050_ \phase[10] _043_ _042_ VDD VSS NOR4
X_201_ _045_ _048_ _049_ _050_ VDD VSS NAND3
X_202_ \phase[10] _045_ _046_ VDD VSS NAND2
X_203_ _063_ _046_ _047_ VDD VSS NAND2
X_204_ tx _047_ _044_ _037_ _026_ VDD VSS OR4
X_205_ clk _097_ VSS _097_ \phase[0] VDD VSS DFFR
X_206_ clk _009_ VSS _099_ \phase[1] VDD VSS DFFR
X_207_ clk _010_ VSS _100_ \phase[2] VDD VSS DFFR
X_208_ clk _011_ VSS _101_ \phase[3] VDD VSS DFFR
X_209_ clk _012_ VSS _102_ \phase[4] VDD VSS DFFR
X_210_ clk _013_ VSS _103_ \phase[5] VDD VSS DFFR
X_211_ clk _014_ VSS _104_ \phase[6] VDD VSS DFFR
X_212_ clk _015_ VSS _105_ \phase[7] VDD VSS DFFR
X_213_ clk _016_ VSS _106_ \phase[8] VDD VSS DFFR
X_214_ clk _017_ VSS _107_ \phase[9] VDD VSS DFFR
X_215_ clk _003_ VSS _108_ \phase[10] VDD VSS DFFR
X_216_ clk _004_ VSS _000_ \phase[11] VDD VSS DFFR
X_217_ clk _005_ VSS _109_ \phase[12] VDD VSS DFFR
X_218_ clk _006_ VSS _002_ \phase[13] VDD VSS DFFR
X_219_ clk _007_ VSS _001_ \phase[14] VDD VSS DFFR
X_220_ clk _008_ VSS _098_ \phase[15] VDD VSS DFFR
.ENDS tr1um_uarttx_big

.SUBCKT AND2_X1 A B Y VDD VSS
* device instance $1 r0 *1 6.1,44.8 PMOS
M$1 \$6 A VDD VDD PMOS L=1U W=10.2U AS=28.56P AD=15.3P PS=26U PD=13.2U
* device instance $2 r0 *1 10.1,44.8 PMOS
M$2 VDD B \$6 VDD PMOS L=1U W=10.2U AS=15.3P AD=15.3P PS=13.2U PD=13.2U
* device instance $3 r0 *1 14.1,44.8 PMOS
M$3 Y \$6 VDD VDD PMOS L=1U W=10.2U AS=15.3P AD=28.56P PS=13.2U PD=26U
* device instance $4 r0 *1 6.1,6.8 NMOS
M$4 \$4 A \$6 VSS NMOS L=1U W=3.4U AS=9.52P AD=5.1P PS=12.4U PD=6.4U
* device instance $5 r0 *1 10.1,6.8 NMOS
M$5 VSS B \$4 VSS NMOS L=1U W=3.4U AS=5.1P AD=5.1P PS=6.4U PD=6.4U
* device instance $6 r0 *1 14.1,6.8 NMOS
M$6 Y \$6 VSS VSS NMOS L=1U W=3.4U AS=5.1P AD=9.52P PS=6.4U PD=12.4U
.ENDS AND2_X1

.SUBCKT AND3_X1 A B Y C VDD VSS
* device instance $1 r0 *1 6.1,44.8 PMOS
M$1 VDD A \$3 VDD PMOS L=1U W=10.2U AS=28.56P AD=15.3P PS=26U PD=13.2U
* device instance $2 r0 *1 10.1,44.8 PMOS
M$2 \$3 B VDD VDD PMOS L=1U W=10.2U AS=15.3P AD=15.3P PS=13.2U PD=13.2U
* device instance $3 r0 *1 14.1,44.8 PMOS
M$3 VDD C \$3 VDD PMOS L=1U W=10.2U AS=15.3P AD=15.3P PS=13.2U PD=13.2U
* device instance $4 r0 *1 18.1,44.8 PMOS
M$4 Y \$3 VDD VDD PMOS L=1U W=10.2U AS=15.3P AD=28.56P PS=13.2U PD=26U
* device instance $5 r0 *1 6.1,6.8 NMOS
M$5 \$5 A \$3 VSS NMOS L=1U W=3.4U AS=9.52P AD=5.1P PS=12.4U PD=6.4U
* device instance $6 r0 *1 10.1,6.8 NMOS
M$6 \$6 B \$5 VSS NMOS L=1U W=3.4U AS=5.1P AD=5.1P PS=6.4U PD=6.4U
* device instance $7 r0 *1 14.1,6.8 NMOS
M$7 VSS C \$6 VSS NMOS L=1U W=3.4U AS=5.1P AD=5.1P PS=6.4U PD=6.4U
* device instance $8 r0 *1 18.1,6.8 NMOS
M$8 Y \$3 VSS VSS NMOS L=1U W=3.4U AS=5.1P AD=9.52P PS=6.4U PD=12.4U
.ENDS AND3_X1

.SUBCKT AND4_X1 A Y C B D VDD VSS
* device instance $1 r0 *1 6.1,44.8 PMOS
M$1 \$2 A VDD VDD PMOS L=1U W=10.2U AS=28.56P AD=15.3P PS=26U PD=13.2U
* device instance $2 r0 *1 10.1,44.8 PMOS
M$2 VDD B \$2 VDD PMOS L=1U W=10.2U AS=15.3P AD=15.3P PS=13.2U PD=13.2U
* device instance $3 r0 *1 14.1,44.8 PMOS
M$3 \$2 C VDD VDD PMOS L=1U W=10.2U AS=15.3P AD=15.3P PS=13.2U PD=13.2U
* device instance $4 r0 *1 18.1,44.8 PMOS
M$4 VDD D \$2 VDD PMOS L=1U W=10.2U AS=15.3P AD=15.3P PS=13.2U PD=13.2U
* device instance $5 r0 *1 22.1,44.8 PMOS
M$5 Y \$2 VDD VDD PMOS L=1U W=10.2U AS=15.3P AD=28.56P PS=13.2U PD=26U
* device instance $6 r0 *1 6.1,6.8 NMOS
M$6 \$4 A \$2 VSS NMOS L=1U W=3.4U AS=9.52P AD=5.1P PS=12.4U PD=6.4U
* device instance $7 r0 *1 10.1,6.8 NMOS
M$7 \$5 B \$4 VSS NMOS L=1U W=3.4U AS=5.1P AD=5.1P PS=6.4U PD=6.4U
* device instance $8 r0 *1 14.1,6.8 NMOS
M$8 \$7 C \$5 VSS NMOS L=1U W=3.4U AS=5.1P AD=5.1P PS=6.4U PD=6.4U
* device instance $9 r0 *1 18.1,6.8 NMOS
M$9 VSS D \$7 VSS NMOS L=1U W=3.4U AS=5.1P AD=5.1P PS=6.4U PD=6.4U
* device instance $10 r0 *1 22.1,6.8 NMOS
M$10 Y \$2 VSS VSS NMOS L=1U W=3.4U AS=5.1P AD=9.52P PS=6.4U PD=12.4U
.ENDS AND4_X1

.SUBCKT DFFR CK D RST QB Q VDD VSS
* device instance $1 r0 *1 50.9,44.8 PMOS
M$1 \$22 \$8 VDD VDD PMOS L=1U W=10.2U AS=28.56P AD=7.14P PS=26U PD=11.6U
* device instance $2 r0 *1 53.3,44.8 PMOS
M$2 \$10 \$5 \$22 VDD PMOS L=1U W=10.2U AS=7.14P AD=15.3P PS=11.6U PD=13.2U
* device instance $3 r0 *1 57.3,44.8 PMOS
M$3 \$23 \$4 \$10 VDD PMOS L=1U W=10.2U AS=15.3P AD=7.14P PS=13.2U PD=11.6U
* device instance $4 r0 *1 59.7,44.8 PMOS
M$4 VDD \$11 \$23 VDD PMOS L=1U W=10.2U AS=7.14P AD=15.3P PS=11.6U PD=13.2U
* device instance $5 r0 *1 63.7,44.8 PMOS
M$5 \$24 \$10 VDD VDD PMOS L=1U W=10.2U AS=15.3P AD=15.3P PS=13.2U PD=13.2U
* device instance $6 r0 *1 67.7,44.8 PMOS
M$6 \$11 RST \$24 VDD PMOS L=1U W=10.2U AS=15.3P AD=28.56P PS=13.2U PD=26U
* device instance $7 r0 *1 32.5,44.8 PMOS
M$7 \$20 \$5 \$7 VDD PMOS L=1U W=10.2U AS=28.56P AD=7.14P PS=26U PD=11.6U
* device instance $8 r0 *1 34.9,44.8 PMOS
M$8 VDD \$8 \$20 VDD PMOS L=1U W=10.2U AS=7.14P AD=15.3P PS=11.6U PD=13.2U
* device instance $9 r0 *1 38.9,44.8 PMOS
M$9 \$21 \$7 VDD VDD PMOS L=1U W=10.2U AS=15.3P AD=15.3P PS=13.2U PD=13.2U
* device instance $10 r0 *1 42.9,44.8 PMOS
M$10 \$8 RST \$21 VDD PMOS L=1U W=10.2U AS=15.3P AD=28.56P PS=13.2U PD=26U
* device instance $11 r0 *1 75.7,44.8 PMOS
M$11 VDD \$11 QB VDD PMOS L=1U W=10.2U AS=28.56P AD=15.3P PS=26U PD=13.2U
* device instance $12 r0 *1 79.7,44.8 PMOS
M$12 Q QB VDD VDD PMOS L=1U W=10.2U AS=15.3P AD=28.56P PS=13.2U PD=26U
* device instance $13 r0 *1 6.1,44.8 PMOS
M$13 VDD CK \$2 VDD PMOS L=1U W=10.2U AS=28.56P AD=15.3P PS=26U PD=13.2U
* device instance $14 r0 *1 10.1,44.8 PMOS
M$14 \$4 \$2 VDD VDD PMOS L=1U W=10.2U AS=15.3P AD=28.56P PS=13.2U PD=26U
* device instance $15 r0 *1 18.1,44.8 PMOS
M$15 VDD \$4 \$5 VDD PMOS L=1U W=10.2U AS=28.56P AD=15.3P PS=26U PD=13.2U
* device instance $16 r0 *1 22.1,44.8 PMOS
M$16 \$19 D VDD VDD PMOS L=1U W=10.2U AS=15.3P AD=7.14P PS=13.2U PD=11.6U
* device instance $17 r0 *1 24.5,44.8 PMOS
M$17 \$7 \$4 \$19 VDD PMOS L=1U W=10.2U AS=7.14P AD=28.56P PS=11.6U PD=26U
* device instance $18 r0 *1 75.7,6.8 NMOS
M$18 VSS \$11 QB VSS NMOS L=1U W=3.4U AS=9.52P AD=5.1P PS=12.4U PD=6.4U
* device instance $19 r0 *1 79.7,6.8 NMOS
M$19 Q QB VSS VSS NMOS L=1U W=3.4U AS=5.1P AD=9.52P PS=6.4U PD=12.4U
* device instance $20 r0 *1 50.9,6.8 NMOS
M$20 \$16 \$8 VSS VSS NMOS L=1U W=3.4U AS=9.52P AD=2.38P PS=12.4U PD=4.8U
* device instance $21 r0 *1 53.3,6.8 NMOS
M$21 \$10 \$4 \$16 VSS NMOS L=1U W=3.4U AS=2.38P AD=5.1P PS=4.8U PD=6.4U
* device instance $22 r0 *1 57.3,6.8 NMOS
M$22 \$17 \$5 \$10 VSS NMOS L=1U W=3.4U AS=5.1P AD=2.38P PS=6.4U PD=4.8U
* device instance $23 r0 *1 59.7,6.8 NMOS
M$23 VSS \$11 \$17 VSS NMOS L=1U W=3.4U AS=2.38P AD=5.1P PS=4.8U PD=6.4U
* device instance $24 r0 *1 63.7,6.8 NMOS
M$24 \$11 \$10 VSS VSS NMOS L=1U W=3.4U AS=5.1P AD=5.1P PS=6.4U PD=6.4U
* device instance $25 r0 *1 67.7,6.8 NMOS
M$25 VSS RST \$11 VSS NMOS L=1U W=3.4U AS=5.1P AD=9.52P PS=6.4U PD=12.4U
* device instance $26 r0 *1 32.5,6.8 NMOS
M$26 \$15 \$4 \$7 VSS NMOS L=1U W=3.4U AS=9.52P AD=2.38P PS=12.4U PD=4.8U
* device instance $27 r0 *1 34.9,6.8 NMOS
M$27 VSS \$8 \$15 VSS NMOS L=1U W=3.4U AS=2.38P AD=5.1P PS=4.8U PD=6.4U
* device instance $28 r0 *1 38.9,6.8 NMOS
M$28 \$8 \$7 VSS VSS NMOS L=1U W=3.4U AS=5.1P AD=5.1P PS=6.4U PD=6.4U
* device instance $29 r0 *1 42.9,6.8 NMOS
M$29 VSS RST \$8 VSS NMOS L=1U W=3.4U AS=5.1P AD=9.52P PS=6.4U PD=12.4U
* device instance $30 r0 *1 6.1,6.8 NMOS
M$30 VSS CK \$2 VSS NMOS L=1U W=3.4U AS=9.52P AD=5.1P PS=12.4U PD=6.4U
* device instance $31 r0 *1 10.1,6.8 NMOS
M$31 \$4 \$2 VSS VSS NMOS L=1U W=3.4U AS=5.1P AD=9.52P PS=6.4U PD=12.4U
* device instance $32 r0 *1 18.1,6.8 NMOS
M$32 VSS \$4 \$5 VSS NMOS L=1U W=3.4U AS=9.52P AD=5.1P PS=12.4U PD=6.4U
* device instance $33 r0 *1 22.1,6.8 NMOS
M$33 \$14 D VSS VSS NMOS L=1U W=3.4U AS=5.1P AD=2.38P PS=6.4U PD=4.8U
* device instance $34 r0 *1 24.5,6.8 NMOS
M$34 \$7 \$5 \$14 VSS NMOS L=1U W=3.4U AS=2.38P AD=9.52P PS=4.8U PD=12.4U
.ENDS DFFR

.SUBCKT INV_X1 A Y VDD VSS
* device instance $1 r0 *1 6.1,44.8 PMOS
M$1 Y A VDD VDD PMOS L=1U W=10.2U AS=28.56P AD=28.56P PS=26U PD=26U
* device instance $2 r0 *1 6.1,6.8 NMOS
M$2 Y A VSS VSS NMOS L=1U W=3.4U AS=9.52P AD=9.52P PS=12.4U PD=12.4U
.ENDS INV_X1

.SUBCKT NAND2 A B Y VDD VSS
* device instance $1 r0 *1 6.1,44.8 PMOS
M$1 Y A VDD VDD PMOS L=1U W=10.2U AS=28.56P AD=15.3P PS=26U PD=13.2U
* device instance $2 r0 *1 10.1,44.8 PMOS
M$2 VDD B Y VDD PMOS L=1U W=10.2U AS=15.3P AD=28.56P PS=13.2U PD=26U
* device instance $3 r0 *1 6.1,6.8 NMOS
M$3 \$6 A VSS VSS NMOS L=1U W=3.4U AS=9.52P AD=5.1P PS=12.4U PD=6.4U
* device instance $4 r0 *1 10.1,6.8 NMOS
M$4 Y B \$6 VSS NMOS L=1U W=3.4U AS=5.1P AD=9.52P PS=6.4U PD=12.4U
.ENDS NAND2

.SUBCKT NAND3 Y A B C VDD VSS
* device instance $1 r0 *1 6.1,44.8 PMOS
M$1 Y A VDD VDD PMOS L=1U W=10.2U AS=28.56P AD=15.3P PS=26U PD=13.2U
* device instance $2 r0 *1 10.1,44.8 PMOS
M$2 VDD B Y VDD PMOS L=1U W=10.2U AS=15.3P AD=15.3P PS=13.2U PD=13.2U
* device instance $3 r0 *1 14.1,44.8 PMOS
M$3 Y C VDD VDD PMOS L=1U W=10.2U AS=15.3P AD=28.56P PS=13.2U PD=26U
* device instance $4 r0 *1 6.1,6.8 NMOS
M$4 \$6 A Y VSS NMOS L=1U W=3.4U AS=9.52P AD=5.1P PS=12.4U PD=6.4U
* device instance $5 r0 *1 10.1,6.8 NMOS
M$5 \$5 B \$6 VSS NMOS L=1U W=3.4U AS=5.1P AD=5.1P PS=6.4U PD=6.4U
* device instance $6 r0 *1 14.1,6.8 NMOS
M$6 VSS C \$5 VSS NMOS L=1U W=3.4U AS=5.1P AD=9.52P PS=6.4U PD=12.4U
.ENDS NAND3

.SUBCKT NAND4 A B Y C D VDD VSS
* device instance $1 r0 *1 6.1,44.8 PMOS
M$1 Y A VDD VDD PMOS L=1U W=10.2U AS=28.56P AD=15.3P PS=26U PD=13.2U
* device instance $2 r0 *1 10.1,44.8 PMOS
M$2 VDD B Y VDD PMOS L=1U W=10.2U AS=15.3P AD=15.3P PS=13.2U PD=13.2U
* device instance $3 r0 *1 14.1,44.8 PMOS
M$3 Y C VDD VDD PMOS L=1U W=10.2U AS=15.3P AD=15.3P PS=13.2U PD=13.2U
* device instance $4 r0 *1 18.1,44.8 PMOS
M$4 VDD D Y VDD PMOS L=1U W=10.2U AS=15.3P AD=28.56P PS=13.2U PD=26U
* device instance $5 r0 *1 6.1,6.8 NMOS
M$5 \$4 A VSS VSS NMOS L=1U W=3.4U AS=9.52P AD=5.1P PS=12.4U PD=6.4U
* device instance $6 r0 *1 10.1,6.8 NMOS
M$6 \$5 B \$4 VSS NMOS L=1U W=3.4U AS=5.1P AD=5.1P PS=6.4U PD=6.4U
* device instance $7 r0 *1 14.1,6.8 NMOS
M$7 \$6 C \$5 VSS NMOS L=1U W=3.4U AS=5.1P AD=5.1P PS=6.4U PD=6.4U
* device instance $8 r0 *1 18.1,6.8 NMOS
M$8 Y D \$6 VSS NMOS L=1U W=3.4U AS=5.1P AD=9.52P PS=6.4U PD=12.4U
.ENDS NAND4

.SUBCKT NOR2 A B Y VDD VSS
* device instance $1 r0 *1 6.1,44.8 PMOS
M$1 \$5 A VDD VDD PMOS L=1U W=10.2U AS=28.56P AD=15.3P PS=26U PD=13.2U
* device instance $2 r0 *1 10.1,44.8 PMOS
M$2 Y B \$5 VDD PMOS L=1U W=10.2U AS=15.3P AD=28.56P PS=13.2U PD=26U
* device instance $3 r0 *1 6.1,6.8 NMOS
M$3 Y A VSS VSS NMOS L=1U W=3.4U AS=9.52P AD=5.1P PS=12.4U PD=6.4U
* device instance $4 r0 *1 10.1,6.8 NMOS
M$4 VSS B Y VSS NMOS L=1U W=3.4U AS=5.1P AD=9.52P PS=6.4U PD=12.4U
.ENDS NOR2

.SUBCKT NOR3 Y A C B VDD VSS
* device instance $1 r0 *1 6.1,44.8 PMOS
M$1 \$7 B VDD VDD PMOS L=1U W=10.2U AS=28.56P AD=15.3P PS=26U PD=13.2U
* device instance $2 r0 *1 10.1,44.8 PMOS
M$2 \$8 A \$7 VDD PMOS L=1U W=10.2U AS=15.3P AD=15.3P PS=13.2U PD=13.2U
* device instance $3 r0 *1 14.1,44.8 PMOS
M$3 Y C \$8 VDD PMOS L=1U W=10.2U AS=15.3P AD=28.56P PS=13.2U PD=26U
* device instance $4 r0 *1 6.1,6.8 NMOS
M$4 Y B VSS VSS NMOS L=1U W=3.4U AS=9.52P AD=5.1P PS=12.4U PD=6.4U
* device instance $5 r0 *1 10.1,6.8 NMOS
M$5 VSS A Y VSS NMOS L=1U W=3.4U AS=5.1P AD=5.1P PS=6.4U PD=6.4U
* device instance $6 r0 *1 14.1,6.8 NMOS
M$6 Y C VSS VSS NMOS L=1U W=3.4U AS=5.1P AD=9.52P PS=6.4U PD=12.4U
.ENDS NOR3

.SUBCKT NOR4 Y A B D C VDD VSS
* device instance $1 r0 *1 6.1,44.8 PMOS
M$1 \$8 A VDD VDD PMOS L=1U W=10.2U AS=28.56P AD=15.3P PS=26U PD=13.2U
* device instance $2 r0 *1 10.1,44.8 PMOS
M$2 \$9 B \$8 VDD PMOS L=1U W=10.2U AS=15.3P AD=15.3P PS=13.2U PD=13.2U
* device instance $3 r0 *1 14.1,44.8 PMOS
M$3 \$10 C \$9 VDD PMOS L=1U W=10.2U AS=15.3P AD=15.3P PS=13.2U PD=13.2U
* device instance $4 r0 *1 18.1,44.8 PMOS
M$4 Y D \$10 VDD PMOS L=1U W=10.2U AS=15.3P AD=28.56P PS=13.2U PD=26U
* device instance $5 r0 *1 6.1,6.8 NMOS
M$5 Y A VSS VSS NMOS L=1U W=3.4U AS=9.52P AD=5.1P PS=12.4U PD=6.4U
* device instance $6 r0 *1 10.1,6.8 NMOS
M$6 VSS B Y VSS NMOS L=1U W=3.4U AS=5.1P AD=5.1P PS=6.4U PD=6.4U
* device instance $7 r0 *1 14.1,6.8 NMOS
M$7 Y C VSS VSS NMOS L=1U W=3.4U AS=5.1P AD=5.1P PS=6.4U PD=6.4U
* device instance $8 r0 *1 18.1,6.8 NMOS
M$8 VSS D Y VSS NMOS L=1U W=3.4U AS=5.1P AD=9.52P PS=6.4U PD=12.4U
.ENDS NOR4

.SUBCKT OR2 A B Y VDD VSS
* device instance $1 r0 *1 6.1,44.8 PMOS
M$1 \$6 A \$5 VDD PMOS L=1U W=10.2U AS=28.56P AD=15.3P PS=26U PD=13.2U
* device instance $2 r0 *1 10.1,44.8 PMOS
M$2 VDD B \$6 VDD PMOS L=1U W=10.2U AS=15.3P AD=15.3P PS=13.2U PD=13.2U
* device instance $3 r0 *1 14.1,44.8 PMOS
M$3 Y \$5 VDD VDD PMOS L=1U W=10.2U AS=15.3P AD=28.56P PS=13.2U PD=26U
* device instance $4 r0 *1 6.1,6.8 NMOS
M$4 \$5 A VSS VSS NMOS L=1U W=3.4U AS=9.52P AD=5.1P PS=12.4U PD=6.4U
* device instance $5 r0 *1 10.1,6.8 NMOS
M$5 VSS B \$5 VSS NMOS L=1U W=3.4U AS=5.1P AD=5.1P PS=6.4U PD=6.4U
* device instance $6 r0 *1 14.1,6.8 NMOS
M$6 Y \$5 VSS VSS NMOS L=1U W=3.4U AS=5.1P AD=9.52P PS=6.4U PD=12.4U
.ENDS OR2

.SUBCKT OR3 Y A C B VDD VSS
* device instance $1 r0 *1 6.1,44.8 PMOS
M$1 \$7 B \$2 VDD PMOS L=1U W=10.2U AS=28.56P AD=15.3P PS=26U PD=13.2U
* device instance $2 r0 *1 10.1,44.8 PMOS
M$2 \$8 A \$7 VDD PMOS L=1U W=10.2U AS=15.3P AD=15.3P PS=13.2U PD=13.2U
* device instance $3 r0 *1 14.1,44.8 PMOS
M$3 VDD C \$8 VDD PMOS L=1U W=10.2U AS=15.3P AD=15.3P PS=13.2U PD=13.2U
* device instance $4 r0 *1 18.1,44.8 PMOS
M$4 Y \$2 VDD VDD PMOS L=1U W=10.2U AS=15.3P AD=28.56P PS=13.2U PD=26U
* device instance $5 r0 *1 6.1,6.8 NMOS
M$5 VSS B \$2 VSS NMOS L=1U W=3.4U AS=9.52P AD=5.1P PS=12.4U PD=6.4U
* device instance $6 r0 *1 10.1,6.8 NMOS
M$6 \$2 A VSS VSS NMOS L=1U W=3.4U AS=5.1P AD=5.1P PS=6.4U PD=6.4U
* device instance $7 r0 *1 14.1,6.8 NMOS
M$7 VSS C \$2 VSS NMOS L=1U W=3.4U AS=5.1P AD=5.1P PS=6.4U PD=6.4U
* device instance $8 r0 *1 18.1,6.8 NMOS
M$8 Y \$2 VSS VSS NMOS L=1U W=3.4U AS=5.1P AD=9.52P PS=6.4U PD=12.4U
.ENDS OR3

.SUBCKT OR4 Y D C B A VDD VSS
* device instance $1 r0 *1 6.1,44.8 PMOS
M$1 \$8 D \$2 VDD PMOS L=1U W=10.2U AS=28.56P AD=15.3P PS=26U PD=13.2U
* device instance $2 r0 *1 10.1,44.8 PMOS
M$2 \$9 C \$8 VDD PMOS L=1U W=10.2U AS=15.3P AD=15.3P PS=13.2U PD=13.2U
* device instance $3 r0 *1 14.1,44.8 PMOS
M$3 \$10 B \$9 VDD PMOS L=1U W=10.2U AS=15.3P AD=15.3P PS=13.2U PD=13.2U
* device instance $4 r0 *1 18.1,44.8 PMOS
M$4 VDD A \$10 VDD PMOS L=1U W=10.2U AS=15.3P AD=15.3P PS=13.2U PD=13.2U
* device instance $5 r0 *1 22.1,44.8 PMOS
M$5 Y \$2 VDD VDD PMOS L=1U W=10.2U AS=15.3P AD=28.56P PS=13.2U PD=26U
* device instance $6 r0 *1 6.1,6.8 NMOS
M$6 \$2 D VSS VSS NMOS L=1U W=3.4U AS=9.52P AD=5.1P PS=12.4U PD=6.4U
* device instance $7 r0 *1 10.1,6.8 NMOS
M$7 VSS C \$2 VSS NMOS L=1U W=3.4U AS=5.1P AD=5.1P PS=6.4U PD=6.4U
* device instance $8 r0 *1 14.1,6.8 NMOS
M$8 \$2 B VSS VSS NMOS L=1U W=3.4U AS=5.1P AD=5.1P PS=6.4U PD=6.4U
* device instance $9 r0 *1 18.1,6.8 NMOS
M$9 VSS A \$2 VSS NMOS L=1U W=3.4U AS=5.1P AD=5.1P PS=6.4U PD=6.4U
* device instance $10 r0 *1 22.1,6.8 NMOS
M$10 Y \$2 VSS VSS NMOS L=1U W=3.4U AS=5.1P AD=9.52P PS=6.4U PD=12.4U
.ENDS OR4

.SUBCKT XNOR2 B Y A VDD VSS
* device instance $1 r0 *1 18.1,44.8 PMOS
M$1 VDD \$4 Y VDD PMOS L=1U W=10.2U AS=28.56P AD=15.3P PS=26U PD=13.2U
* device instance $2 r0 *1 22.1,44.8 PMOS
M$2 \$9 B VDD VDD PMOS L=1U W=10.2U AS=15.3P AD=15.3P PS=13.2U PD=13.2U
* device instance $3 r0 *1 26.1,44.8 PMOS
M$3 Y A \$9 VDD PMOS L=1U W=10.2U AS=15.3P AD=28.56P PS=13.2U PD=26U
* device instance $4 r0 *1 6.1,44.8 PMOS
M$4 VDD A \$4 VDD PMOS L=1U W=10.2U AS=28.56P AD=15.3P PS=26U PD=13.2U
* device instance $5 r0 *1 10.1,44.8 PMOS
M$5 \$4 B VDD VDD PMOS L=1U W=10.2U AS=15.3P AD=28.56P PS=13.2U PD=26U
* device instance $6 r0 *1 18.1,6.8 NMOS
M$6 \$6 \$4 Y VSS NMOS L=1U W=3.4U AS=9.52P AD=5.1P PS=12.4U PD=6.4U
* device instance $7 r0 *1 22.1,6.8 NMOS
M$7 VSS B \$6 VSS NMOS L=1U W=3.4U AS=5.1P AD=5.1P PS=6.4U PD=6.4U
* device instance $8 r0 *1 26.1,6.8 NMOS
M$8 \$6 A VSS VSS NMOS L=1U W=3.4U AS=5.1P AD=9.52P PS=6.4U PD=12.4U
* device instance $9 r0 *1 6.1,6.8 NMOS
M$9 \$2 A VSS VSS NMOS L=1U W=3.4U AS=9.52P AD=5.1P PS=12.4U PD=6.4U
* device instance $10 r0 *1 10.1,6.8 NMOS
M$10 \$4 B \$2 VSS NMOS L=1U W=3.4U AS=5.1P AD=9.52P PS=6.4U PD=12.4U
.ENDS XNOR2

.SUBCKT XOR2 B Y A VDD VSS
* device instance $1 r0 *1 18.1,44.8 PMOS
M$1 \$9 \$2 Y VDD PMOS L=1U W=10.2U AS=28.56P AD=15.3P PS=26U PD=13.2U
* device instance $2 r0 *1 22.1,44.8 PMOS
M$2 VDD B \$9 VDD PMOS L=1U W=10.2U AS=15.3P AD=15.3P PS=13.2U PD=13.2U
* device instance $3 r0 *1 26.1,44.8 PMOS
M$3 \$9 A VDD VDD PMOS L=1U W=10.2U AS=15.3P AD=28.56P PS=13.2U PD=26U
* device instance $4 r0 *1 6.1,44.8 PMOS
M$4 \$8 A VDD VDD PMOS L=1U W=10.2U AS=28.56P AD=15.3P PS=26U PD=13.2U
* device instance $5 r0 *1 10.1,44.8 PMOS
M$5 \$2 B \$8 VDD PMOS L=1U W=10.2U AS=15.3P AD=28.56P PS=13.2U PD=26U
* device instance $6 r0 *1 18.1,6.8 NMOS
M$6 VSS \$2 Y VSS NMOS L=1U W=3.4U AS=9.52P AD=5.1P PS=12.4U PD=6.4U
* device instance $7 r0 *1 22.1,6.8 NMOS
M$7 \$5 B VSS VSS NMOS L=1U W=3.4U AS=5.1P AD=5.1P PS=6.4U PD=6.4U
* device instance $8 r0 *1 26.1,6.8 NMOS
M$8 Y A \$5 VSS NMOS L=1U W=3.4U AS=5.1P AD=9.52P PS=6.4U PD=12.4U
* device instance $9 r0 *1 6.1,6.8 NMOS
M$9 VSS A \$2 VSS NMOS L=1U W=3.4U AS=9.52P AD=5.1P PS=12.4U PD=6.4U
* device instance $10 r0 *1 10.1,6.8 NMOS
M$10 \$2 B VSS VSS NMOS L=1U W=3.4U AS=5.1P AD=9.52P PS=6.4U PD=12.4U
.ENDS XOR2
