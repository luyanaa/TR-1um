.SUBCKT CMC_S_NMOS_B_X1_Y1 G DA SA DB SB GND
M1 DA G SA GND NMOS L=1U W=3.4U AS=9.52P AD=9.52P PS=12.4U PD=12.4U
M2 DB G SB GND NMOS L=1U W=3.4U AS=9.52P AD=9.52P PS=12.4U PD=12.4U
.ENDS CMC_S_NMOS_B_X1_Y1
